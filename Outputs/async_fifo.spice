* NGSPICE file created from async_fifo.ext - technology: sky130A

* Black-box entry subcircuit for sky130_fd_sc_hd__mux2_1 abstract view
.subckt sky130_fd_sc_hd__mux2_1 A0 A1 S VGND VNB VPB VPWR X
.ends

* Black-box entry subcircuit for sky130_fd_sc_hd__tapvpwrvgnd_1 abstract view
.subckt sky130_fd_sc_hd__tapvpwrvgnd_1 VGND VPWR
.ends

* Black-box entry subcircuit for sky130_fd_sc_hd__fill_2 abstract view
.subckt sky130_fd_sc_hd__fill_2 VGND VNB VPB VPWR
.ends

* Black-box entry subcircuit for sky130_fd_sc_hd__o2111ai_4 abstract view
.subckt sky130_fd_sc_hd__o2111ai_4 A1 A2 B1 C1 D1 VGND VNB VPB VPWR Y
.ends

* Black-box entry subcircuit for sky130_fd_sc_hd__fill_1 abstract view
.subckt sky130_fd_sc_hd__fill_1 VGND VNB VPB VPWR
.ends

* Black-box entry subcircuit for sky130_ef_sc_hd__decap_12 abstract view
.subckt sky130_ef_sc_hd__decap_12 VPWR VGND VPB VNB
.ends

* Black-box entry subcircuit for sky130_fd_sc_hd__decap_3 abstract view
.subckt sky130_fd_sc_hd__decap_3 VGND VNB VPB VPWR
.ends

* Black-box entry subcircuit for sky130_fd_sc_hd__dfxtp_1 abstract view
.subckt sky130_fd_sc_hd__dfxtp_1 CLK D VGND VNB VPB VPWR Q
.ends

* Black-box entry subcircuit for sky130_fd_sc_hd__and4_1 abstract view
.subckt sky130_fd_sc_hd__and4_1 A B C D VGND VNB VPB VPWR X
.ends

* Black-box entry subcircuit for sky130_fd_sc_hd__dfxtp_2 abstract view
.subckt sky130_fd_sc_hd__dfxtp_2 CLK D VGND VNB VPB VPWR Q
.ends

* Black-box entry subcircuit for sky130_fd_sc_hd__nor2_4 abstract view
.subckt sky130_fd_sc_hd__nor2_4 A B VGND VNB VPB VPWR Y
.ends

* Black-box entry subcircuit for sky130_fd_sc_hd__a221o_1 abstract view
.subckt sky130_fd_sc_hd__a221o_1 A1 A2 B1 B2 C1 VGND VNB VPB VPWR X
.ends

* Black-box entry subcircuit for sky130_fd_sc_hd__or2b_4 abstract view
.subckt sky130_fd_sc_hd__or2b_4 A B_N VGND VNB VPB VPWR X
.ends

* Black-box entry subcircuit for sky130_fd_sc_hd__nor2_1 abstract view
.subckt sky130_fd_sc_hd__nor2_1 A B VGND VNB VPB VPWR Y
.ends

* Black-box entry subcircuit for sky130_fd_sc_hd__decap_6 abstract view
.subckt sky130_fd_sc_hd__decap_6 VGND VNB VPB VPWR
.ends

* Black-box entry subcircuit for sky130_fd_sc_hd__a31oi_1 abstract view
.subckt sky130_fd_sc_hd__a31oi_1 A1 A2 A3 B1 VGND VNB VPB VPWR Y
.ends

* Black-box entry subcircuit for sky130_fd_sc_hd__clkbuf_1 abstract view
.subckt sky130_fd_sc_hd__clkbuf_1 A VGND VNB VPB VPWR X
.ends

* Black-box entry subcircuit for sky130_fd_sc_hd__decap_4 abstract view
.subckt sky130_fd_sc_hd__decap_4 VGND VNB VPB VPWR
.ends

* Black-box entry subcircuit for sky130_fd_sc_hd__and2b_1 abstract view
.subckt sky130_fd_sc_hd__and2b_1 A_N B VGND VNB VPB VPWR X
.ends

* Black-box entry subcircuit for sky130_fd_sc_hd__buf_1 abstract view
.subckt sky130_fd_sc_hd__buf_1 A VGND VNB VPB VPWR X
.ends

* Black-box entry subcircuit for sky130_fd_sc_hd__xnor2_2 abstract view
.subckt sky130_fd_sc_hd__xnor2_2 A B VGND VNB VPB VPWR Y
.ends

* Black-box entry subcircuit for sky130_fd_sc_hd__a21oi_1 abstract view
.subckt sky130_fd_sc_hd__a21oi_1 A1 A2 B1 VGND VNB VPB VPWR Y
.ends

* Black-box entry subcircuit for sky130_fd_sc_hd__decap_8 abstract view
.subckt sky130_fd_sc_hd__decap_8 VGND VNB VPB VPWR
.ends

* Black-box entry subcircuit for sky130_fd_sc_hd__a31o_1 abstract view
.subckt sky130_fd_sc_hd__a31o_1 A1 A2 A3 B1 VGND VNB VPB VPWR X
.ends

* Black-box entry subcircuit for sky130_fd_sc_hd__o31a_1 abstract view
.subckt sky130_fd_sc_hd__o31a_1 A1 A2 A3 B1 VGND VNB VPB VPWR X
.ends

* Black-box entry subcircuit for sky130_fd_sc_hd__nand2_1 abstract view
.subckt sky130_fd_sc_hd__nand2_1 A B VGND VNB VPB VPWR Y
.ends

* Black-box entry subcircuit for sky130_fd_sc_hd__o21bai_1 abstract view
.subckt sky130_fd_sc_hd__o21bai_1 A1 A2 B1_N VGND VNB VPB VPWR Y
.ends

* Black-box entry subcircuit for sky130_fd_sc_hd__or4bb_4 abstract view
.subckt sky130_fd_sc_hd__or4bb_4 A B C_N D_N VGND VNB VPB VPWR X
.ends

* Black-box entry subcircuit for sky130_fd_sc_hd__or2b_1 abstract view
.subckt sky130_fd_sc_hd__or2b_1 A B_N VGND VNB VPB VPWR X
.ends

* Black-box entry subcircuit for sky130_fd_sc_hd__nand2b_4 abstract view
.subckt sky130_fd_sc_hd__nand2b_4 A_N B VGND VNB VPB VPWR Y
.ends

* Black-box entry subcircuit for sky130_fd_sc_hd__and3_2 abstract view
.subckt sky130_fd_sc_hd__and3_2 A B C VGND VNB VPB VPWR X
.ends

* Black-box entry subcircuit for sky130_fd_sc_hd__dfxtp_4 abstract view
.subckt sky130_fd_sc_hd__dfxtp_4 CLK D VGND VNB VPB VPWR Q
.ends

* Black-box entry subcircuit for sky130_fd_sc_hd__o211a_1 abstract view
.subckt sky130_fd_sc_hd__o211a_1 A1 A2 B1 C1 VGND VNB VPB VPWR X
.ends

* Black-box entry subcircuit for sky130_fd_sc_hd__inv_2 abstract view
.subckt sky130_fd_sc_hd__inv_2 A VGND VNB VPB VPWR Y
.ends

* Black-box entry subcircuit for sky130_fd_sc_hd__and4b_4 abstract view
.subckt sky130_fd_sc_hd__and4b_4 A_N B C D VGND VNB VPB VPWR X
.ends

* Black-box entry subcircuit for sky130_fd_sc_hd__and2_1 abstract view
.subckt sky130_fd_sc_hd__and2_1 A B VGND VNB VPB VPWR X
.ends

* Black-box entry subcircuit for sky130_fd_sc_hd__or2_4 abstract view
.subckt sky130_fd_sc_hd__or2_4 A B VGND VNB VPB VPWR X
.ends

* Black-box entry subcircuit for sky130_fd_sc_hd__clkbuf_4 abstract view
.subckt sky130_fd_sc_hd__clkbuf_4 A VGND VNB VPB VPWR X
.ends

* Black-box entry subcircuit for sky130_fd_sc_hd__buf_4 abstract view
.subckt sky130_fd_sc_hd__buf_4 A VGND VNB VPB VPWR X
.ends

* Black-box entry subcircuit for sky130_fd_sc_hd__buf_2 abstract view
.subckt sky130_fd_sc_hd__buf_2 A VGND VNB VPB VPWR X
.ends

* Black-box entry subcircuit for sky130_fd_sc_hd__o31a_2 abstract view
.subckt sky130_fd_sc_hd__o31a_2 A1 A2 A3 B1 VGND VNB VPB VPWR X
.ends

* Black-box entry subcircuit for sky130_fd_sc_hd__xnor2_1 abstract view
.subckt sky130_fd_sc_hd__xnor2_1 A B VGND VNB VPB VPWR Y
.ends

* Black-box entry subcircuit for sky130_fd_sc_hd__nor3_1 abstract view
.subckt sky130_fd_sc_hd__nor3_1 A B C VGND VNB VPB VPWR Y
.ends

* Black-box entry subcircuit for sky130_fd_sc_hd__a211oi_1 abstract view
.subckt sky130_fd_sc_hd__a211oi_1 A1 A2 B1 C1 VGND VNB VPB VPWR Y
.ends

* Black-box entry subcircuit for sky130_fd_sc_hd__o2111ai_2 abstract view
.subckt sky130_fd_sc_hd__o2111ai_2 A1 A2 B1 C1 D1 VGND VNB VPB VPWR Y
.ends

* Black-box entry subcircuit for sky130_fd_sc_hd__nand3b_4 abstract view
.subckt sky130_fd_sc_hd__nand3b_4 A_N B C VGND VNB VPB VPWR Y
.ends

* Black-box entry subcircuit for sky130_fd_sc_hd__or2_1 abstract view
.subckt sky130_fd_sc_hd__or2_1 A B VGND VNB VPB VPWR X
.ends

* Black-box entry subcircuit for sky130_fd_sc_hd__clkbuf_2 abstract view
.subckt sky130_fd_sc_hd__clkbuf_2 A VGND VNB VPB VPWR X
.ends

* Black-box entry subcircuit for sky130_fd_sc_hd__and3_1 abstract view
.subckt sky130_fd_sc_hd__and3_1 A B C VGND VNB VPB VPWR X
.ends

* Black-box entry subcircuit for sky130_fd_sc_hd__o21bai_2 abstract view
.subckt sky130_fd_sc_hd__o21bai_2 A1 A2 B1_N VGND VNB VPB VPWR Y
.ends

* Black-box entry subcircuit for sky130_fd_sc_hd__or3b_1 abstract view
.subckt sky130_fd_sc_hd__or3b_1 A B C_N VGND VNB VPB VPWR X
.ends

* Black-box entry subcircuit for sky130_fd_sc_hd__o21ai_1 abstract view
.subckt sky130_fd_sc_hd__o21ai_1 A1 A2 B1 VGND VNB VPB VPWR Y
.ends

* Black-box entry subcircuit for sky130_fd_sc_hd__buf_8 abstract view
.subckt sky130_fd_sc_hd__buf_8 A VGND VNB VPB VPWR X
.ends

* Black-box entry subcircuit for sky130_fd_sc_hd__a2111o_1 abstract view
.subckt sky130_fd_sc_hd__a2111o_1 A1 A2 B1 C1 D1 VGND VNB VPB VPWR X
.ends

* Black-box entry subcircuit for sky130_fd_sc_hd__o21ba_1 abstract view
.subckt sky130_fd_sc_hd__o21ba_1 A1 A2 B1_N VGND VNB VPB VPWR X
.ends

* Black-box entry subcircuit for sky130_fd_sc_hd__xor2_1 abstract view
.subckt sky130_fd_sc_hd__xor2_1 A B VGND VNB VPB VPWR X
.ends

* Black-box entry subcircuit for sky130_fd_sc_hd__a311oi_1 abstract view
.subckt sky130_fd_sc_hd__a311oi_1 A1 A2 A3 B1 C1 VGND VNB VPB VPWR Y
.ends

* Black-box entry subcircuit for sky130_fd_sc_hd__nand2_4 abstract view
.subckt sky130_fd_sc_hd__nand2_4 A B VGND VNB VPB VPWR Y
.ends

* Black-box entry subcircuit for sky130_fd_sc_hd__or4b_4 abstract view
.subckt sky130_fd_sc_hd__or4b_4 A B C D_N VGND VNB VPB VPWR X
.ends

* Black-box entry subcircuit for sky130_fd_sc_hd__o21a_1 abstract view
.subckt sky130_fd_sc_hd__o21a_1 A1 A2 B1 VGND VNB VPB VPWR X
.ends

* Black-box entry subcircuit for sky130_fd_sc_hd__nor3_2 abstract view
.subckt sky130_fd_sc_hd__nor3_2 A B C VGND VNB VPB VPWR Y
.ends

.subckt async_fifo VGND VPWR din[0] din[1] din[2] din[3] din[4] din[5] din[6] din[7]
+ dout[0] dout[1] dout[2] dout[3] dout[4] dout[5] dout[6] dout[7] empty full rd_clk
+ rd_en rst wr_clk wr_en
Xu_mem._0518_ u_mem.mem\[4\]\[1\] u_mem._0141_ u_mem._0157_ VGND VGND VPWR VPWR u_mem._0159_
+ sky130_fd_sc_hd__mux2_1
XTAP_177 VGND VPWR sky130_fd_sc_hd__tapvpwrvgnd_1
XTAP_188 VGND VPWR sky130_fd_sc_hd__tapvpwrvgnd_1
XTAP_199 VGND VPWR sky130_fd_sc_hd__tapvpwrvgnd_1
XFILLER_0_17_222 VGND VGND VPWR VPWR sky130_fd_sc_hd__fill_2
Xu_write._60_ u_write._23_ u_write._24_ u_write._25_ u_write._26_ u_write._27_ VGND
+ VGND VPWR VPWR u_write._28_ sky130_fd_sc_hd__o2111ai_4
XFILLER_0_32_269 VGND VGND VPWR VPWR sky130_fd_sc_hd__fill_1
XFILLER_0_23_225 VPWR VGND VPWR VGND sky130_ef_sc_hd__decap_12
XFILLER_0_23_269 VGND VGND VPWR VPWR sky130_fd_sc_hd__fill_1
XFILLER_0_3_39 VPWR VGND VPWR VGND sky130_ef_sc_hd__decap_12
XFILLER_0_14_269 VGND VGND VPWR VPWR sky130_fd_sc_hd__fill_1
XFILLER_0_38_81 VGND VGND VPWR VPWR sky130_fd_sc_hd__decap_3
Xu_mem._0998_ wr_clk u_mem._0026_ VGND VGND VPWR VPWR u_mem.mem\[8\]\[2\] sky130_fd_sc_hd__dfxtp_1
Xu_write._43_ u_mem.wr_addr\[3\] u_mem.wr_addr\[2\] u_mem.wr_addr\[1\] u_mem.wr_addr\[0\]
+ VGND VGND VPWR VPWR u_write._11_ sky130_fd_sc_hd__and4_1
Xu_read._94_ rd_clk u_read._07_ VGND VGND VPWR VPWR u_mem.rd_addr\[2\] sky130_fd_sc_hd__dfxtp_2
XFILLER_0_18_29 VPWR VGND VPWR VGND sky130_ef_sc_hd__decap_12
Xu_mem._0921_ u_mem._0137_ u_mem._0156_ VGND VGND VPWR VPWR u_mem._0459_ sky130_fd_sc_hd__nor2_4
Xu_mem._0783_ u_mem._0349_ u_mem._0352_ u_mem._0354_ u_mem._0356_ u_mem.rd_addr\[3\]
+ VGND VGND VPWR VPWR u_mem._0357_ sky130_fd_sc_hd__a221o_1
Xu_mem._0852_ u_mem.wr_addr\[1\] u_mem.wr_addr\[0\] VGND VGND VPWR VPWR u_mem._0422_
+ sky130_fd_sc_hd__or2b_4
Xu_sync_wr2rd._40_ rd_clk u_sync_wr2rd._00_ VGND VGND VPWR VPWR u_read.wr_gray_sync2\[0\]
+ sky130_fd_sc_hd__dfxtp_1
XFILLER_0_6_266 VGND VGND VPWR VPWR sky130_fd_sc_hd__fill_1
XFILLER_0_24_83 VGND VGND VPWR VPWR sky130_fd_sc_hd__fill_1
XFILLER_0_4_82 VGND VGND VPWR VPWR sky130_fd_sc_hd__fill_2
XFILLER_0_37_169 VGND VGND VPWR VPWR sky130_fd_sc_hd__decap_3
Xu_read._77_ u_read._36_ u_read._37_ VGND VGND VPWR VPWR u_read._04_ sky130_fd_sc_hd__nor2_1
XFILLER_0_29_39 VGND VGND VPWR VPWR sky130_fd_sc_hd__decap_6
XFILLER_0_45_27 VGND VGND VPWR VPWR sky130_fd_sc_hd__fill_1
XFILLER_0_0_29 VPWR VGND VPWR VGND sky130_ef_sc_hd__decap_12
Xu_mem._1051_ rd_clk u_mem._0079_ VGND VGND VPWR VPWR u_mem.dout\[7\] sky130_fd_sc_hd__dfxtp_1
XFILLER_0_3_258 VPWR VGND VPWR VGND sky130_ef_sc_hd__decap_12
XFILLER_0_10_41 VPWR VGND VPWR VGND sky130_ef_sc_hd__decap_12
XFILLER_0_10_74 VGND VGND VPWR VPWR sky130_fd_sc_hd__decap_3
XFILLER_0_10_85 VPWR VGND VPWR VGND sky130_ef_sc_hd__decap_12
Xu_mem._0904_ u_mem._0176_ u_mem._0195_ VGND VGND VPWR VPWR u_mem._0450_ sky130_fd_sc_hd__nor2_4
Xu_mem._0835_ u_mem.mem\[8\]\[7\] u_mem.mem\[9\]\[7\] u_mem._0248_ VGND VGND VPWR
+ VPWR u_mem._0406_ sky130_fd_sc_hd__mux2_1
Xu_mem._0697_ u_mem._0234_ u_mem._0257_ u_mem._0273_ u_mem._0274_ VGND VGND VPWR VPWR
+ u_mem._0072_ sky130_fd_sc_hd__a31oi_1
XFILLER_0_19_50 VGND VGND VPWR VPWR sky130_fd_sc_hd__decap_6
XFILLER_0_19_61 VGND VGND VPWR VPWR sky130_fd_sc_hd__fill_1
Xu_mem._0766_ u_mem._0258_ u_mem.mem\[12\]\[4\] VGND VGND VPWR VPWR u_mem._0340_ sky130_fd_sc_hd__nor2_1
Xu_sync_wr2rd._23_ u_sync_wr2rd._11_ VGND VGND VPWR VPWR u_sync_wr2rd._01_ sky130_fd_sc_hd__clkbuf_1
XFILLER_0_34_139 VGND VGND VPWR VPWR sky130_fd_sc_hd__fill_1
Xu_mem._0620_ u_mem._0155_ u_mem._0195_ VGND VGND VPWR VPWR u_mem._0214_ sky130_fd_sc_hd__nor2_4
Xu_mem._0551_ u_mem._0156_ u_mem._0176_ VGND VGND VPWR VPWR u_mem._0177_ sky130_fd_sc_hd__nor2_4
Xu_mem._1103_ wr_clk u_mem._0131_ VGND VGND VPWR VPWR u_mem.mem\[9\]\[3\] sky130_fd_sc_hd__dfxtp_1
Xu_mem._1034_ wr_clk u_mem._0062_ VGND VGND VPWR VPWR u_mem.mem\[6\]\[6\] sky130_fd_sc_hd__dfxtp_1
Xu_mem._0749_ u_mem.mem\[10\]\[3\] u_mem.mem\[11\]\[3\] u_mem._0252_ VGND VGND VPWR
+ VPWR u_mem._0324_ sky130_fd_sc_hd__mux2_1
Xu_mem._0818_ u_mem.mem\[6\]\[6\] u_mem.mem\[7\]\[6\] u_mem._0237_ VGND VGND VPWR
+ VPWR u_mem._0390_ sky130_fd_sc_hd__mux2_1
XFILLER_0_34_3 VGND VGND VPWR VPWR sky130_fd_sc_hd__decap_6
XFILLER_0_15_150 VGND VGND VPWR VPWR sky130_fd_sc_hd__fill_2
XFILLER_0_15_172 VGND VGND VPWR VPWR sky130_fd_sc_hd__fill_1
XFILLER_0_30_153 VGND VGND VPWR VPWR sky130_fd_sc_hd__decap_4
XFILLER_0_26_29 VGND VGND VPWR VPWR sky130_fd_sc_hd__decap_3
XFILLER_0_30_197 VGND VGND VPWR VPWR sky130_fd_sc_hd__fill_1
XTAP_304 VGND VPWR sky130_fd_sc_hd__tapvpwrvgnd_1
XFILLER_0_21_164 VGND VGND VPWR VPWR sky130_fd_sc_hd__fill_1
Xu_mem._0534_ u_mem._0136_ u_mem.mem\[12\]\[0\] u_mem._0167_ VGND VGND VPWR VPWR u_mem._0168_
+ sky130_fd_sc_hd__mux2_1
Xu_mem._0603_ u_mem._0138_ u_mem._0155_ VGND VGND VPWR VPWR u_mem._0205_ sky130_fd_sc_hd__nor2_4
Xu_sync_rd2wr._34_ net10 u_read.rd_ptr_gray\[2\] VGND VGND VPWR VPWR u_sync_rd2wr._17_
+ sky130_fd_sc_hd__and2b_1
XFILLER_0_8_158 VGND VGND VPWR VPWR sky130_fd_sc_hd__fill_2
Xu_mem._1017_ wr_clk u_mem._0045_ VGND VGND VPWR VPWR u_mem.mem\[2\]\[5\] sky130_fd_sc_hd__dfxtp_1
XFILLER_0_12_197 VGND VGND VPWR VPWR sky130_fd_sc_hd__fill_1
XFILLER_0_7_180 VGND VGND VPWR VPWR sky130_fd_sc_hd__fill_1
Xoutput20 net20 VGND VGND VPWR VPWR empty sky130_fd_sc_hd__buf_1
XFILLER_0_37_28 VPWR VGND VPWR VGND sky130_ef_sc_hd__decap_12
XTAP_134 VGND VPWR sky130_fd_sc_hd__tapvpwrvgnd_1
XTAP_123 VGND VPWR sky130_fd_sc_hd__tapvpwrvgnd_1
XTAP_112 VGND VPWR sky130_fd_sc_hd__tapvpwrvgnd_1
XTAP_101 VGND VPWR sky130_fd_sc_hd__tapvpwrvgnd_1
XTAP_145 VGND VPWR sky130_fd_sc_hd__tapvpwrvgnd_1
XTAP_156 VGND VPWR sky130_fd_sc_hd__tapvpwrvgnd_1
XTAP_167 VGND VPWR sky130_fd_sc_hd__tapvpwrvgnd_1
XTAP_178 VGND VPWR sky130_fd_sc_hd__tapvpwrvgnd_1
XTAP_189 VGND VPWR sky130_fd_sc_hd__tapvpwrvgnd_1
Xu_mem._0517_ u_mem._0158_ VGND VGND VPWR VPWR u_mem._0008_ sky130_fd_sc_hd__clkbuf_1
XFILLER_0_4_150 VGND VGND VPWR VPWR sky130_fd_sc_hd__decap_6
XFILLER_0_23_237 VPWR VGND VPWR VGND sky130_ef_sc_hd__decap_12
XFILLER_0_1_175 VGND VGND VPWR VPWR sky130_fd_sc_hd__fill_1
XFILLER_0_38_93 VGND VGND VPWR VPWR sky130_fd_sc_hd__fill_1
Xu_mem._0997_ wr_clk u_mem._0025_ VGND VGND VPWR VPWR u_mem.mem\[8\]\[1\] sky130_fd_sc_hd__dfxtp_1
Xu_write._42_ u_mem.wr_addr\[3\] u_write._09_ VGND VGND VPWR VPWR u_write._10_ sky130_fd_sc_hd__xnor2_2
Xu_read._93_ rd_clk u_read._06_ VGND VGND VPWR VPWR u_mem.rd_addr\[1\] sky130_fd_sc_hd__dfxtp_2
Xu_mem._0920_ u_mem._0458_ VGND VGND VPWR VPWR u_mem._0111_ sky130_fd_sc_hd__clkbuf_1
Xu_mem._0782_ u_mem._0251_ u_mem._0355_ u_mem._0254_ VGND VGND VPWR VPWR u_mem._0356_
+ sky130_fd_sc_hd__a21oi_1
Xu_mem._0851_ u_mem._0234_ u_mem._0410_ u_mem._0420_ u_mem._0421_ VGND VGND VPWR VPWR
+ u_mem._0079_ sky130_fd_sc_hd__a31oi_1
XFILLER_0_40_94 VGND VGND VPWR VPWR sky130_fd_sc_hd__decap_8
XFILLER_0_40_83 VGND VGND VPWR VPWR sky130_fd_sc_hd__fill_1
XFILLER_0_10_251 VGND VGND VPWR VPWR sky130_fd_sc_hd__fill_1
XFILLER_0_4_94 VPWR VGND VPWR VGND sky130_ef_sc_hd__decap_12
XFILLER_0_45_181 VPWR VGND VPWR VGND sky130_ef_sc_hd__decap_12
Xu_read._76_ u_read.rd_ptr_bin\[4\] u_read._19_ u_read._35_ net10 VGND VGND VPWR VPWR
+ u_read._37_ sky130_fd_sc_hd__a31o_1
XFILLER_0_0_19 VGND VGND VPWR VPWR sky130_fd_sc_hd__decap_8
XFILLER_0_43_129 VGND VGND VPWR VPWR sky130_fd_sc_hd__fill_2
Xu_mem._1050_ rd_clk u_mem._0078_ VGND VGND VPWR VPWR u_mem.dout\[6\] sky130_fd_sc_hd__dfxtp_1
XFILLER_0_10_53 VGND VGND VPWR VPWR sky130_fd_sc_hd__fill_2
XFILLER_0_10_64 VGND VGND VPWR VPWR sky130_fd_sc_hd__decap_4
XFILLER_0_10_97 VPWR VGND VPWR VGND sky130_ef_sc_hd__decap_12
Xu_mem._0834_ u_mem._0235_ u_mem._0403_ u_mem._0404_ u_mem.rd_addr\[2\] VGND VGND
+ VPWR VPWR u_mem._0405_ sky130_fd_sc_hd__o31a_1
Xu_mem._0903_ u_mem._0449_ VGND VGND VPWR VPWR u_mem._0103_ sky130_fd_sc_hd__clkbuf_1
Xu_mem._0696_ u_mem.dout\[0\] u_mem._0234_ VGND VGND VPWR VPWR u_mem._0274_ sky130_fd_sc_hd__nor2_1
Xu_mem._0765_ u_mem._0269_ u_mem._0338_ VGND VGND VPWR VPWR u_mem._0339_ sky130_fd_sc_hd__nand2_1
XFILLER_0_19_148 VPWR VGND VPWR VGND sky130_ef_sc_hd__decap_12
Xu_sync_wr2rd._22_ net10 u_sync_wr2rd.gray_sync1\[1\] VGND VGND VPWR VPWR u_sync_wr2rd._11_
+ sky130_fd_sc_hd__and2b_1
Xu_read._59_ u_mem.rd_addr\[1\] u_mem.rd_addr\[0\] u_mem.rd_addr\[2\] VGND VGND VPWR
+ VPWR u_read._23_ sky130_fd_sc_hd__o21bai_1
Xu_mem._0550_ u_mem.wr_addr\[2\] net21 net11 u_mem.wr_addr\[3\] VGND VGND VPWR VPWR
+ u_mem._0176_ sky130_fd_sc_hd__or4bb_4
Xu_mem._1102_ wr_clk u_mem._0130_ VGND VGND VPWR VPWR u_mem.mem\[9\]\[2\] sky130_fd_sc_hd__dfxtp_1
XFILLER_0_21_96 VGND VGND VPWR VPWR sky130_fd_sc_hd__decap_4
Xu_mem._1033_ wr_clk u_mem._0061_ VGND VGND VPWR VPWR u_mem.mem\[6\]\[5\] sky130_fd_sc_hd__dfxtp_1
XFILLER_0_24_151 VPWR VGND VPWR VGND sky130_ef_sc_hd__decap_12
Xu_mem._0817_ u_mem._0381_ u_mem._0384_ u_mem._0386_ u_mem._0388_ u_mem._0256_ VGND
+ VGND VPWR VPWR u_mem._0389_ sky130_fd_sc_hd__a221o_1
Xu_mem._0679_ u_mem._0239_ u_mem._0246_ u_mem._0250_ u_mem._0255_ u_mem._0256_ VGND
+ VGND VPWR VPWR u_mem._0257_ sky130_fd_sc_hd__a221o_1
XFILLER_0_1_51 VGND VGND VPWR VPWR sky130_fd_sc_hd__decap_4
Xu_mem._0748_ u_mem._0247_ u_mem._0322_ VGND VGND VPWR VPWR u_mem._0323_ sky130_fd_sc_hd__or2b_1
XFILLER_0_27_3 VGND VGND VPWR VPWR sky130_fd_sc_hd__decap_8
XFILLER_0_15_140 VGND VGND VPWR VPWR sky130_fd_sc_hd__decap_6
XFILLER_0_42_29 VGND VGND VPWR VPWR sky130_fd_sc_hd__decap_8
XFILLER_0_21_110 VGND VGND VPWR VPWR sky130_fd_sc_hd__fill_2
XTAP_305 VGND VPWR sky130_fd_sc_hd__tapvpwrvgnd_1
XFILLER_0_21_187 VPWR VGND VPWR VGND sky130_ef_sc_hd__decap_12
Xu_mem._0602_ u_mem._0204_ VGND VGND VPWR VPWR u_mem._0047_ sky130_fd_sc_hd__clkbuf_1
Xu_mem._0533_ u_mem._0156_ u_mem._0166_ VGND VGND VPWR VPWR u_mem._0167_ sky130_fd_sc_hd__nand2b_4
XFILLER_0_16_41 VGND VGND VPWR VPWR sky130_fd_sc_hd__fill_2
XFILLER_0_16_85 VGND VGND VPWR VPWR sky130_fd_sc_hd__fill_1
XFILLER_0_44_235 VPWR VGND VPWR VGND sky130_ef_sc_hd__decap_12
Xu_sync_rd2wr._33_ u_sync_rd2wr._16_ VGND VGND VPWR VPWR u_sync_rd2wr._06_ sky130_fd_sc_hd__clkbuf_1
XFILLER_0_32_51 VGND VGND VPWR VPWR sky130_fd_sc_hd__decap_4
XFILLER_0_12_187 VGND VGND VPWR VPWR sky130_fd_sc_hd__fill_1
Xu_mem._1016_ wr_clk u_mem._0044_ VGND VGND VPWR VPWR u_mem.mem\[2\]\[4\] sky130_fd_sc_hd__dfxtp_1
Xoutput21 net21 VGND VGND VPWR VPWR full sky130_fd_sc_hd__buf_1
XFILLER_0_5_107 VGND VGND VPWR VPWR sky130_fd_sc_hd__decap_4
XFILLER_0_26_213 VGND VGND VPWR VPWR sky130_fd_sc_hd__decap_6
XFILLER_0_5_129 VGND VGND VPWR VPWR sky130_fd_sc_hd__fill_1
XTAP_135 VGND VPWR sky130_fd_sc_hd__tapvpwrvgnd_1
XTAP_124 VGND VPWR sky130_fd_sc_hd__tapvpwrvgnd_1
XTAP_113 VGND VPWR sky130_fd_sc_hd__tapvpwrvgnd_1
XTAP_102 VGND VPWR sky130_fd_sc_hd__tapvpwrvgnd_1
XTAP_146 VGND VPWR sky130_fd_sc_hd__tapvpwrvgnd_1
XTAP_157 VGND VPWR sky130_fd_sc_hd__tapvpwrvgnd_1
XTAP_168 VGND VPWR sky130_fd_sc_hd__tapvpwrvgnd_1
XTAP_179 VGND VPWR sky130_fd_sc_hd__tapvpwrvgnd_1
XFILLER_0_27_40 VPWR VGND VPWR VGND sky130_ef_sc_hd__decap_12
Xu_mem._0516_ u_mem.mem\[4\]\[0\] u_mem._0136_ u_mem._0157_ VGND VGND VPWR VPWR u_mem._0158_
+ sky130_fd_sc_hd__mux2_1
XFILLER_0_27_73 VGND VGND VPWR VPWR sky130_fd_sc_hd__decap_6
XFILLER_0_27_95 VGND VGND VPWR VPWR sky130_fd_sc_hd__fill_2
XFILLER_0_23_249 VPWR VGND VPWR VGND sky130_ef_sc_hd__decap_12
XFILLER_0_31_260 VGND VGND VPWR VPWR sky130_fd_sc_hd__decap_6
Xu_mem._0996_ wr_clk u_mem._0024_ VGND VGND VPWR VPWR u_mem.mem\[8\]\[0\] sky130_fd_sc_hd__dfxtp_1
XFILLER_0_1_110 VGND VGND VPWR VPWR sky130_fd_sc_hd__fill_2
Xu_write._41_ u_mem.wr_addr\[2\] u_mem.wr_addr\[1\] u_mem.wr_addr\[0\] VGND VGND VPWR
+ VPWR u_write._09_ sky130_fd_sc_hd__and3_2
Xu_read._92_ rd_clk u_read._05_ VGND VGND VPWR VPWR u_mem.rd_addr\[0\] sky130_fd_sc_hd__dfxtp_4
Xu_mem._0850_ u_mem.dout\[7\] u_mem._0233_ VGND VGND VPWR VPWR u_mem._0421_ sky130_fd_sc_hd__nor2_1
Xu_mem._0781_ u_mem.mem\[2\]\[4\] u_mem.mem\[3\]\[4\] u_mem._0270_ VGND VGND VPWR
+ VPWR u_mem._0355_ sky130_fd_sc_hd__mux2_1
XFILLER_0_6_235 VGND VGND VPWR VPWR sky130_fd_sc_hd__fill_1
Xu_mem._0979_ wr_clk u_mem._0007_ VGND VGND VPWR VPWR u_mem.mem\[3\]\[7\] sky130_fd_sc_hd__dfxtp_1
XFILLER_0_45_193 VGND VGND VPWR VPWR sky130_fd_sc_hd__decap_3
Xu_read._75_ u_read._20_ u_read._35_ u_read.rd_ptr_bin\[4\] VGND VGND VPWR VPWR u_read._36_
+ sky130_fd_sc_hd__a21oi_1
XFILLER_0_45_29 VPWR VGND VPWR VGND sky130_ef_sc_hd__decap_12
Xu_mem._0902_ u_mem._0153_ u_mem.mem\[15\]\[7\] u_mem._0441_ VGND VGND VPWR VPWR u_mem._0449_
+ sky130_fd_sc_hd__mux2_1
Xu_mem._0764_ u_mem.mem\[14\]\[4\] u_mem.mem\[15\]\[4\] u_mem._0237_ VGND VGND VPWR
+ VPWR u_mem._0338_ sky130_fd_sc_hd__mux2_1
Xu_mem._0833_ u_mem.mem\[13\]\[7\] u_mem._0266_ VGND VGND VPWR VPWR u_mem._0404_ sky130_fd_sc_hd__and2b_1
Xu_mem._0695_ u_mem._0260_ u_mem._0264_ u_mem._0268_ u_mem._0272_ u_mem.rd_addr\[3\]
+ VGND VGND VPWR VPWR u_mem._0273_ sky130_fd_sc_hd__a221o_1
XFILLER_0_19_138 VGND VGND VPWR VPWR sky130_fd_sc_hd__fill_1
Xu_sync_wr2rd._21_ u_sync_wr2rd._10_ VGND VGND VPWR VPWR u_sync_wr2rd._00_ sky130_fd_sc_hd__clkbuf_1
XFILLER_0_18_171 VGND VGND VPWR VPWR sky130_fd_sc_hd__fill_2
XFILLER_0_25_119 VGND VGND VPWR VPWR sky130_fd_sc_hd__fill_1
Xu_read._58_ u_read.rd_ptr_gray\[0\] u_read._20_ u_read._21_ u_read._22_ VGND VGND
+ VPWR VPWR u_read._00_ sky130_fd_sc_hd__o211a_1
Xu_mem._1101_ wr_clk u_mem._0129_ VGND VGND VPWR VPWR u_mem.mem\[9\]\[1\] sky130_fd_sc_hd__dfxtp_1
Xu_mem._1032_ wr_clk u_mem._0060_ VGND VGND VPWR VPWR u_mem.mem\[6\]\[4\] sky130_fd_sc_hd__dfxtp_1
XFILLER_0_21_53 VGND VGND VPWR VPWR sky130_fd_sc_hd__decap_3
Xu_mem._0747_ u_mem.mem\[8\]\[3\] u_mem.mem\[9\]\[3\] u_mem._0248_ VGND VGND VPWR
+ VPWR u_mem._0322_ sky130_fd_sc_hd__mux2_1
Xu_mem._0816_ u_mem._0265_ u_mem._0387_ u_mem._0263_ VGND VGND VPWR VPWR u_mem._0388_
+ sky130_fd_sc_hd__a21oi_1
Xu_mem._0678_ u_mem.rd_addr\[3\] VGND VGND VPWR VPWR u_mem._0256_ sky130_fd_sc_hd__inv_2
XFILLER_0_30_166 VGND VGND VPWR VPWR sky130_fd_sc_hd__fill_1
XFILLER_0_6_19 VGND VGND VPWR VPWR sky130_fd_sc_hd__decap_8
XFILLER_0_21_100 VGND VGND VPWR VPWR sky130_fd_sc_hd__fill_1
XTAP_306 VGND VPWR sky130_fd_sc_hd__tapvpwrvgnd_1
XFILLER_0_21_199 VGND VGND VPWR VPWR sky130_fd_sc_hd__fill_1
Xu_mem._0601_ u_mem.mem\[2\]\[7\] u_mem._0153_ u_mem._0196_ VGND VGND VPWR VPWR u_mem._0204_
+ sky130_fd_sc_hd__mux2_1
Xu_mem._0532_ net21 net11 u_mem.wr_addr\[3\] u_mem.wr_addr\[2\] VGND VGND VPWR VPWR
+ u_mem._0166_ sky130_fd_sc_hd__and4b_4
XFILLER_0_29_211 VGND VGND VPWR VPWR sky130_fd_sc_hd__fill_1
XFILLER_0_44_269 VGND VGND VPWR VPWR sky130_fd_sc_hd__fill_1
XFILLER_0_44_247 VGND VGND VPWR VPWR sky130_fd_sc_hd__decap_4
Xu_sync_rd2wr._32_ net10 u_read.rd_ptr_gray\[1\] VGND VGND VPWR VPWR u_sync_rd2wr._16_
+ sky130_fd_sc_hd__and2b_1
XFILLER_0_8_127 VGND VGND VPWR VPWR sky130_fd_sc_hd__fill_2
Xu_mem._1015_ wr_clk u_mem._0043_ VGND VGND VPWR VPWR u_mem.mem\[2\]\[3\] sky130_fd_sc_hd__dfxtp_1
XFILLER_0_12_166 VGND VGND VPWR VPWR sky130_fd_sc_hd__decap_6
XFILLER_0_9_3 VGND VGND VPWR VPWR sky130_fd_sc_hd__fill_1
XTAP_114 VGND VPWR sky130_fd_sc_hd__tapvpwrvgnd_1
XTAP_103 VGND VPWR sky130_fd_sc_hd__tapvpwrvgnd_1
XTAP_136 VGND VPWR sky130_fd_sc_hd__tapvpwrvgnd_1
XTAP_125 VGND VPWR sky130_fd_sc_hd__tapvpwrvgnd_1
XTAP_147 VGND VPWR sky130_fd_sc_hd__tapvpwrvgnd_1
XTAP_158 VGND VPWR sky130_fd_sc_hd__tapvpwrvgnd_1
XTAP_169 VGND VPWR sky130_fd_sc_hd__tapvpwrvgnd_1
XFILLER_0_27_52 VGND VGND VPWR VPWR sky130_fd_sc_hd__fill_1
Xu_mem._0515_ u_mem._0155_ u_mem._0156_ VGND VGND VPWR VPWR u_mem._0157_ sky130_fd_sc_hd__nor2_4
XFILLER_0_17_225 VPWR VGND VPWR VGND sky130_ef_sc_hd__decap_12
XFILLER_0_17_269 VGND VGND VPWR VPWR sky130_fd_sc_hd__fill_1
XFILLER_0_13_54 VGND VGND VPWR VPWR sky130_fd_sc_hd__fill_2
XFILLER_0_22_250 VGND VGND VPWR VPWR sky130_fd_sc_hd__fill_2
Xu_mem._0995_ wr_clk u_mem._0023_ VGND VGND VPWR VPWR u_mem.mem\[12\]\[7\] sky130_fd_sc_hd__dfxtp_1
XFILLER_0_38_73 VGND VGND VPWR VPWR sky130_fd_sc_hd__decap_8
XFILLER_0_9_211 VGND VGND VPWR VPWR sky130_fd_sc_hd__decap_8
Xu_read._91_ rd_clk u_read._04_ VGND VGND VPWR VPWR u_read.rd_ptr_bin\[4\] sky130_fd_sc_hd__dfxtp_2
XFILLER_0_0_7 VPWR VGND VPWR VGND sky130_ef_sc_hd__decap_12
Xu_mem._0780_ u_mem._0265_ u_mem._0353_ VGND VGND VPWR VPWR u_mem._0354_ sky130_fd_sc_hd__or2b_1
XFILLER_0_40_85 VGND VGND VPWR VPWR sky130_fd_sc_hd__fill_1
XFILLER_0_4_41 VPWR VGND VPWR VGND sky130_ef_sc_hd__decap_12
XFILLER_0_10_253 VPWR VGND VPWR VGND sky130_ef_sc_hd__decap_12
Xu_mem._0978_ wr_clk u_mem._0006_ VGND VGND VPWR VPWR u_mem.mem\[3\]\[6\] sky130_fd_sc_hd__dfxtp_1
Xu_read._74_ u_mem.rd_addr\[3\] u_read._30_ VGND VGND VPWR VPWR u_read._35_ sky130_fd_sc_hd__and2_1
XFILLER_0_45_19 VGND VGND VPWR VPWR sky130_fd_sc_hd__decap_8
XFILLER_0_28_117 VGND VGND VPWR VPWR sky130_fd_sc_hd__decap_4
XFILLER_0_10_11 VGND VGND VPWR VPWR sky130_fd_sc_hd__fill_2
XFILLER_0_10_22 VGND VGND VPWR VPWR sky130_fd_sc_hd__decap_6
Xu_mem._0901_ u_mem._0448_ VGND VGND VPWR VPWR u_mem._0102_ sky130_fd_sc_hd__clkbuf_1
Xu_mem._0763_ u_mem._0234_ u_mem._0326_ u_mem._0336_ u_mem._0337_ VGND VGND VPWR VPWR
+ u_mem._0075_ sky130_fd_sc_hd__a31oi_1
Xu_mem._0832_ u_mem._0258_ u_mem.mem\[12\]\[7\] VGND VGND VPWR VPWR u_mem._0403_ sky130_fd_sc_hd__nor2_1
Xu_mem._0694_ u_mem._0269_ u_mem._0271_ u_mem._0254_ VGND VGND VPWR VPWR u_mem._0272_
+ sky130_fd_sc_hd__a21oi_1
Xu_sync_wr2rd._20_ net10 u_sync_wr2rd.gray_sync1\[0\] VGND VGND VPWR VPWR u_sync_wr2rd._10_
+ sky130_fd_sc_hd__and2b_1
XFILLER_0_27_150 VGND VGND VPWR VPWR sky130_fd_sc_hd__decap_8
XFILLER_0_34_109 VGND VGND VPWR VPWR sky130_fd_sc_hd__decap_4
XFILLER_0_0_209 VPWR VGND VPWR VGND sky130_ef_sc_hd__decap_12
Xu_read._57_ net10 VGND VGND VPWR VPWR u_read._22_ sky130_fd_sc_hd__inv_2
Xu_mem._1100_ wr_clk u_mem._0128_ VGND VGND VPWR VPWR u_mem.mem\[9\]\[0\] sky130_fd_sc_hd__dfxtp_1
Xu_mem._1031_ wr_clk u_mem._0059_ VGND VGND VPWR VPWR u_mem.mem\[6\]\[3\] sky130_fd_sc_hd__dfxtp_1
XFILLER_0_21_65 VGND VGND VPWR VPWR sky130_fd_sc_hd__fill_1
XFILLER_0_24_197 VGND VGND VPWR VPWR sky130_fd_sc_hd__decap_4
Xu_mem._0677_ u_mem._0251_ u_mem._0253_ u_mem._0254_ VGND VGND VPWR VPWR u_mem._0255_
+ sky130_fd_sc_hd__a21oi_1
Xu_mem._0746_ u_mem._0240_ u_mem._0319_ u_mem._0320_ u_mem._0245_ VGND VGND VPWR VPWR
+ u_mem._0321_ sky130_fd_sc_hd__o31a_1
Xu_mem._0815_ u_mem.mem\[10\]\[6\] u_mem.mem\[11\]\[6\] u_mem._0252_ VGND VGND VPWR
+ VPWR u_mem._0387_ sky130_fd_sc_hd__mux2_1
XFILLER_0_1_75 VGND VGND VPWR VPWR sky130_fd_sc_hd__fill_1
XFILLER_0_30_101 VGND VGND VPWR VPWR sky130_fd_sc_hd__fill_1
XFILLER_0_38_201 VGND VGND VPWR VPWR sky130_fd_sc_hd__fill_1
XTAP_307 VGND VPWR sky130_fd_sc_hd__tapvpwrvgnd_1
Xu_mem._0531_ u_mem._0165_ VGND VGND VPWR VPWR u_mem._0015_ sky130_fd_sc_hd__clkbuf_1
Xu_mem._0600_ u_mem._0203_ VGND VGND VPWR VPWR u_mem._0046_ sky130_fd_sc_hd__clkbuf_1
Xu_sync_rd2wr._31_ u_sync_rd2wr._15_ VGND VGND VPWR VPWR u_sync_rd2wr._05_ sky130_fd_sc_hd__clkbuf_1
Xu_mem._1014_ wr_clk u_mem._0042_ VGND VGND VPWR VPWR u_mem.mem\[2\]\[2\] sky130_fd_sc_hd__dfxtp_1
XFILLER_0_12_156 VGND VGND VPWR VPWR sky130_fd_sc_hd__fill_2
Xu_mem._0729_ u_mem._0297_ u_mem._0300_ u_mem._0302_ u_mem._0304_ u_mem._0256_ VGND
+ VGND VPWR VPWR u_mem._0305_ sky130_fd_sc_hd__a221o_1
XFILLER_0_32_3 VPWR VGND VPWR VGND sky130_ef_sc_hd__decap_12
XFILLER_0_7_172 VGND VGND VPWR VPWR sky130_fd_sc_hd__fill_1
Xoutput12 net12 VGND VGND VPWR VPWR dout[0] sky130_fd_sc_hd__clkbuf_1
XFILLER_0_41_207 VPWR VGND VPWR VGND sky130_ef_sc_hd__decap_12
XTAP_126 VGND VPWR sky130_fd_sc_hd__tapvpwrvgnd_1
XTAP_115 VGND VPWR sky130_fd_sc_hd__tapvpwrvgnd_1
XTAP_104 VGND VPWR sky130_fd_sc_hd__tapvpwrvgnd_1
XTAP_137 VGND VPWR sky130_fd_sc_hd__tapvpwrvgnd_1
XTAP_148 VGND VPWR sky130_fd_sc_hd__tapvpwrvgnd_1
XTAP_159 VGND VPWR sky130_fd_sc_hd__tapvpwrvgnd_1
Xu_mem._0514_ u_mem.wr_addr\[0\] u_mem.wr_addr\[1\] VGND VGND VPWR VPWR u_mem._0156_
+ sky130_fd_sc_hd__or2_4
XFILLER_0_43_74 VGND VGND VPWR VPWR sky130_fd_sc_hd__fill_1
XFILLER_0_17_237 VPWR VGND VPWR VGND sky130_ef_sc_hd__decap_12
XFILLER_0_4_175 VGND VGND VPWR VPWR sky130_fd_sc_hd__decap_4
XFILLER_0_38_85 VGND VGND VPWR VPWR sky130_fd_sc_hd__fill_1
XFILLER_0_1_167 VGND VGND VPWR VPWR sky130_fd_sc_hd__fill_1
Xu_mem._0994_ wr_clk u_mem._0022_ VGND VGND VPWR VPWR u_mem.mem\[12\]\[6\] sky130_fd_sc_hd__dfxtp_1
XFILLER_0_9_234 VPWR VGND VPWR VGND sky130_ef_sc_hd__decap_12
Xu_read._90_ rd_clk u_read._03_ VGND VGND VPWR VPWR u_read.rd_ptr_gray\[3\] sky130_fd_sc_hd__dfxtp_1
XFILLER_0_24_76 VGND VGND VPWR VPWR sky130_fd_sc_hd__decap_3
XFILLER_0_4_53 VPWR VGND VPWR VGND sky130_ef_sc_hd__decap_12
XFILLER_0_10_265 VGND VGND VPWR VPWR sky130_fd_sc_hd__decap_4
Xu_mem._0977_ wr_clk u_mem._0005_ VGND VGND VPWR VPWR u_mem.mem\[3\]\[5\] sky130_fd_sc_hd__dfxtp_1
XFILLER_0_37_118 VGND VGND VPWR VPWR sky130_fd_sc_hd__decap_6
Xu_read._73_ u_read._34_ VGND VGND VPWR VPWR u_read._03_ sky130_fd_sc_hd__clkbuf_1
XFILLER_0_36_195 VGND VGND VPWR VPWR sky130_fd_sc_hd__fill_1
XFILLER_0_36_184 VGND VGND VPWR VPWR sky130_fd_sc_hd__decap_4
Xu_mem._0900_ u_mem._0151_ u_mem.mem\[15\]\[6\] u_mem._0441_ VGND VGND VPWR VPWR u_mem._0448_
+ sky130_fd_sc_hd__mux2_1
Xu_mem._0693_ u_mem.mem\[2\]\[0\] u_mem.mem\[3\]\[0\] u_mem._0270_ VGND VGND VPWR
+ VPWR u_mem._0271_ sky130_fd_sc_hd__mux2_1
Xu_mem._0762_ u_mem.dout\[3\] u_mem._0233_ VGND VGND VPWR VPWR u_mem._0337_ sky130_fd_sc_hd__nor2_1
Xu_mem._0831_ u_mem._0269_ u_mem._0401_ VGND VGND VPWR VPWR u_mem._0402_ sky130_fd_sc_hd__nand2_1
XFILLER_0_27_184 VGND VGND VPWR VPWR sky130_fd_sc_hd__fill_1
Xu_read._56_ u_mem.rd_addr\[1\] u_read._20_ VGND VGND VPWR VPWR u_read._21_ sky130_fd_sc_hd__nand2_1
XFILLER_0_33_187 VGND VGND VPWR VPWR sky130_fd_sc_hd__decap_3
XFILLER_0_18_195 VGND VGND VPWR VPWR sky130_fd_sc_hd__fill_1
Xu_mem._1030_ wr_clk u_mem._0058_ VGND VGND VPWR VPWR u_mem.mem\[6\]\[2\] sky130_fd_sc_hd__dfxtp_1
XFILLER_0_21_33 VGND VGND VPWR VPWR sky130_fd_sc_hd__fill_1
Xu_mem._0814_ u_mem._0247_ u_mem._0385_ VGND VGND VPWR VPWR u_mem._0386_ sky130_fd_sc_hd__or2b_1
Xu_mem._0745_ u_mem.mem\[13\]\[3\] u_mem._0243_ VGND VGND VPWR VPWR u_mem._0320_ sky130_fd_sc_hd__and2b_1
Xu_mem._0676_ u_mem.rd_addr\[2\] VGND VGND VPWR VPWR u_mem._0254_ sky130_fd_sc_hd__clkbuf_4
Xu_mem._0530_ u_mem.mem\[4\]\[7\] u_mem._0153_ u_mem._0157_ VGND VGND VPWR VPWR u_mem._0165_
+ sky130_fd_sc_hd__mux2_1
Xu_sync_rd2wr._30_ net10 u_read.rd_ptr_gray\[0\] VGND VGND VPWR VPWR u_sync_rd2wr._15_
+ sky130_fd_sc_hd__and2b_1
XFILLER_0_16_66 VPWR VGND VPWR VGND sky130_ef_sc_hd__decap_12
XFILLER_0_16_99 VPWR VGND VPWR VGND sky130_ef_sc_hd__decap_12
Xu_mem._1013_ wr_clk u_mem._0041_ VGND VGND VPWR VPWR u_mem.mem\[2\]\[1\] sky130_fd_sc_hd__dfxtp_1
Xu_mem._0728_ u_mem._0251_ u_mem._0303_ u_mem._0263_ VGND VGND VPWR VPWR u_mem._0304_
+ sky130_fd_sc_hd__a21oi_1
XFILLER_0_25_3 VGND VGND VPWR VPWR sky130_fd_sc_hd__fill_1
Xu_mem._0659_ u_mem.rd_addr\[0\] VGND VGND VPWR VPWR u_mem._0237_ sky130_fd_sc_hd__buf_4
XFILLER_0_35_205 VGND VGND VPWR VPWR sky130_fd_sc_hd__decap_4
XFILLER_0_7_151 VGND VGND VPWR VPWR sky130_fd_sc_hd__fill_1
Xoutput13 net13 VGND VGND VPWR VPWR dout[1] sky130_fd_sc_hd__clkbuf_1
XFILLER_0_41_219 VGND VGND VPWR VPWR sky130_fd_sc_hd__fill_2
XFILLER_0_26_249 VGND VGND VPWR VPWR sky130_fd_sc_hd__decap_3
XTAP_127 VGND VPWR sky130_fd_sc_hd__tapvpwrvgnd_1
XTAP_116 VGND VPWR sky130_fd_sc_hd__tapvpwrvgnd_1
XTAP_105 VGND VPWR sky130_fd_sc_hd__tapvpwrvgnd_1
XTAP_138 VGND VPWR sky130_fd_sc_hd__tapvpwrvgnd_1
XTAP_149 VGND VPWR sky130_fd_sc_hd__tapvpwrvgnd_1
Xu_mem._0513_ u_mem.wr_addr\[3\] net21 net11 u_mem.wr_addr\[2\] VGND VGND VPWR VPWR
+ u_mem._0155_ sky130_fd_sc_hd__or4bb_4
XFILLER_0_43_97 VGND VGND VPWR VPWR sky130_fd_sc_hd__decap_3
XFILLER_0_17_205 VGND VGND VPWR VPWR sky130_fd_sc_hd__decap_8
XFILLER_0_17_249 VPWR VGND VPWR VGND sky130_ef_sc_hd__decap_12
XFILLER_0_22_230 VPWR VGND VPWR VGND sky130_ef_sc_hd__decap_12
Xu_mem._0993_ wr_clk u_mem._0021_ VGND VGND VPWR VPWR u_mem.mem\[12\]\[5\] sky130_fd_sc_hd__dfxtp_1
XFILLER_0_9_246 VPWR VGND VPWR VGND sky130_ef_sc_hd__decap_12
Xu_mem._0976_ wr_clk u_mem._0004_ VGND VGND VPWR VPWR u_mem.mem\[3\]\[4\] sky130_fd_sc_hd__dfxtp_1
XFILLER_0_4_65 VGND VGND VPWR VPWR sky130_fd_sc_hd__decap_8
Xu_read._72_ u_read._22_ u_read._33_ VGND VGND VPWR VPWR u_read._34_ sky130_fd_sc_hd__and2_1
XFILLER_0_36_174 VGND VGND VPWR VPWR sky130_fd_sc_hd__decap_4
Xu_mem._0830_ u_mem.mem\[14\]\[7\] u_mem.mem\[15\]\[7\] u_mem._0270_ VGND VGND VPWR
+ VPWR u_mem._0401_ sky130_fd_sc_hd__mux2_1
Xu_mem._0761_ u_mem._0328_ u_mem._0331_ u_mem._0333_ u_mem._0335_ u_mem.rd_addr\[3\]
+ VGND VGND VPWR VPWR u_mem._0336_ sky130_fd_sc_hd__a221o_1
XFILLER_0_19_88 VPWR VGND VPWR VGND sky130_ef_sc_hd__decap_12
Xu_mem._0692_ u_mem.rd_addr\[0\] VGND VGND VPWR VPWR u_mem._0270_ sky130_fd_sc_hd__buf_4
XFILLER_0_42_133 VGND VGND VPWR VPWR sky130_fd_sc_hd__decap_6
XFILLER_0_42_122 VGND VGND VPWR VPWR sky130_fd_sc_hd__fill_2
Xu_mem._0959_ u_mem._0479_ VGND VGND VPWR VPWR u_mem._0129_ sky130_fd_sc_hd__clkbuf_1
XFILLER_0_18_130 VGND VGND VPWR VPWR sky130_fd_sc_hd__decap_3
XFILLER_0_18_141 VPWR VGND VPWR VGND sky130_ef_sc_hd__decap_12
Xu_read._55_ u_read._19_ VGND VGND VPWR VPWR u_read._20_ sky130_fd_sc_hd__buf_2
Xu_mem._0744_ u_mem._0258_ u_mem.mem\[12\]\[3\] VGND VGND VPWR VPWR u_mem._0319_ sky130_fd_sc_hd__nor2_1
Xu_mem._0813_ u_mem.mem\[8\]\[6\] u_mem.mem\[9\]\[6\] u_mem._0248_ VGND VGND VPWR
+ VPWR u_mem._0385_ sky130_fd_sc_hd__mux2_1
Xu_mem._0675_ u_mem.mem\[10\]\[0\] u_mem.mem\[11\]\[0\] u_mem._0252_ VGND VGND VPWR
+ VPWR u_mem._0253_ sky130_fd_sc_hd__mux2_1
XFILLER_0_1_55 VGND VGND VPWR VPWR sky130_fd_sc_hd__fill_1
Xu_mem._1089_ wr_clk u_mem._0117_ VGND VGND VPWR VPWR u_mem.mem\[0\]\[5\] sky130_fd_sc_hd__dfxtp_1
XFILLER_0_16_23 VGND VGND VPWR VPWR sky130_fd_sc_hd__decap_4
XFILLER_0_16_78 VGND VGND VPWR VPWR sky130_fd_sc_hd__fill_1
XFILLER_0_44_206 VPWR VGND VPWR VGND sky130_ef_sc_hd__decap_12
Xu_mem._1012_ wr_clk u_mem._0040_ VGND VGND VPWR VPWR u_mem.mem\[2\]\[0\] sky130_fd_sc_hd__dfxtp_1
XFILLER_0_29_269 VGND VGND VPWR VPWR sky130_fd_sc_hd__fill_1
XFILLER_0_12_136 VGND VGND VPWR VPWR sky130_fd_sc_hd__decap_4
Xu_mem._0727_ u_mem.mem\[10\]\[2\] u_mem.mem\[11\]\[2\] u_mem._0252_ VGND VGND VPWR
+ VPWR u_mem._0303_ sky130_fd_sc_hd__mux2_1
Xu_mem._0589_ u_mem.mem\[2\]\[1\] u_mem._0141_ u_mem._0196_ VGND VGND VPWR VPWR u_mem._0198_
+ sky130_fd_sc_hd__mux2_1
XFILLER_0_18_3 VGND VGND VPWR VPWR sky130_fd_sc_hd__decap_6
Xu_mem._0658_ u_mem._0235_ VGND VGND VPWR VPWR u_mem._0236_ sky130_fd_sc_hd__clkbuf_4
XFILLER_0_43_261 VGND VGND VPWR VPWR sky130_fd_sc_hd__decap_8
XFILLER_0_11_180 VPWR VGND VPWR VGND sky130_ef_sc_hd__decap_12
Xoutput14 net14 VGND VGND VPWR VPWR dout[2] sky130_fd_sc_hd__clkbuf_1
XTAP_128 VGND VPWR sky130_fd_sc_hd__tapvpwrvgnd_1
XTAP_117 VGND VPWR sky130_fd_sc_hd__tapvpwrvgnd_1
XTAP_106 VGND VPWR sky130_fd_sc_hd__tapvpwrvgnd_1
XTAP_139 VGND VPWR sky130_fd_sc_hd__tapvpwrvgnd_1
XFILLER_0_27_11 VGND VGND VPWR VPWR sky130_fd_sc_hd__fill_2
XFILLER_0_43_54 VGND VGND VPWR VPWR sky130_fd_sc_hd__fill_2
Xu_mem._0512_ u_mem._0154_ VGND VGND VPWR VPWR u_mem._0007_ sky130_fd_sc_hd__clkbuf_1
XPHY_0 VGND VGND VPWR VPWR sky130_fd_sc_hd__decap_3
XFILLER_0_40_253 VPWR VGND VPWR VGND sky130_ef_sc_hd__decap_12
XFILLER_0_7_43 VGND VGND VPWR VPWR sky130_fd_sc_hd__decap_4
XFILLER_0_4_188 VGND VGND VPWR VPWR sky130_fd_sc_hd__decap_8
XFILLER_0_7_3 VGND VGND VPWR VPWR sky130_fd_sc_hd__decap_3
XFILLER_0_1_169 VGND VGND VPWR VPWR sky130_fd_sc_hd__decap_6
Xu_mem._0992_ wr_clk u_mem._0020_ VGND VGND VPWR VPWR u_mem.mem\[12\]\[4\] sky130_fd_sc_hd__dfxtp_1
XFILLER_0_22_242 VGND VGND VPWR VPWR sky130_fd_sc_hd__decap_8
XFILLER_0_22_253 VPWR VGND VPWR VGND sky130_ef_sc_hd__decap_12
XFILLER_0_9_258 VPWR VGND VPWR VGND sky130_ef_sc_hd__decap_12
XFILLER_0_39_150 VPWR VGND VPWR VGND sky130_ef_sc_hd__decap_12
XFILLER_0_24_23 VGND VGND VPWR VPWR sky130_fd_sc_hd__decap_4
Xu_mem._0975_ wr_clk u_mem._0003_ VGND VGND VPWR VPWR u_mem.mem\[3\]\[3\] sky130_fd_sc_hd__dfxtp_1
XFILLER_0_45_153 VPWR VGND VPWR VGND sky130_ef_sc_hd__decap_12
XFILLER_0_37_109 VGND VGND VPWR VPWR sky130_fd_sc_hd__decap_3
XFILLER_0_45_197 VPWR VGND VPWR VGND sky130_ef_sc_hd__decap_12
Xu_read._71_ u_read.rd_ptr_gray\[3\] u_read._32_ u_read._19_ VGND VGND VPWR VPWR u_read._33_
+ sky130_fd_sc_hd__mux2_1
XFILLER_0_36_197 VGND VGND VPWR VPWR sky130_fd_sc_hd__decap_8
XFILLER_0_36_120 VPWR VGND VPWR VGND sky130_ef_sc_hd__decap_12
Xu_mem._0760_ u_mem._0269_ u_mem._0334_ u_mem._0254_ VGND VGND VPWR VPWR u_mem._0335_
+ sky130_fd_sc_hd__a21oi_1
XFILLER_0_19_23 VPWR VGND VPWR VGND sky130_ef_sc_hd__decap_12
XFILLER_0_35_55 VGND VGND VPWR VPWR sky130_fd_sc_hd__fill_1
XFILLER_0_19_78 VGND VGND VPWR VPWR sky130_fd_sc_hd__fill_1
Xu_mem._0691_ u_mem._0235_ VGND VGND VPWR VPWR u_mem._0269_ sky130_fd_sc_hd__clkbuf_4
XFILLER_0_42_101 VGND VGND VPWR VPWR sky130_fd_sc_hd__decap_4
XFILLER_0_2_253 VPWR VGND VPWR VGND sky130_ef_sc_hd__decap_12
XFILLER_0_2_220 VPWR VGND VPWR VGND sky130_ef_sc_hd__decap_12
Xu_mem._0958_ u_mem.mem\[9\]\[1\] net2 u_mem._0477_ VGND VGND VPWR VPWR u_mem._0479_
+ sky130_fd_sc_hd__mux2_1
Xu_mem._0889_ u_mem._0442_ VGND VGND VPWR VPWR u_mem._0096_ sky130_fd_sc_hd__clkbuf_1
XFILLER_0_18_153 VPWR VGND VPWR VGND sky130_ef_sc_hd__decap_12
XFILLER_0_18_197 VGND VGND VPWR VPWR sky130_fd_sc_hd__decap_8
Xu_read._54_ u_read._09_ u_read._14_ u_read._18_ net9 VGND VGND VPWR VPWR u_read._19_
+ sky130_fd_sc_hd__o31a_2
XFILLER_0_21_57 VGND VGND VPWR VPWR sky130_fd_sc_hd__decap_8
Xu_mem._0743_ u_mem._0269_ u_mem._0317_ VGND VGND VPWR VPWR u_mem._0318_ sky130_fd_sc_hd__nand2_1
Xu_mem._0812_ u_mem._0235_ u_mem._0382_ u_mem._0383_ u_mem.rd_addr\[2\] VGND VGND
+ VPWR VPWR u_mem._0384_ sky130_fd_sc_hd__o31a_1
XFILLER_0_34_9 VGND VGND VPWR VPWR sky130_fd_sc_hd__fill_1
Xu_mem._0674_ u_mem.rd_addr\[0\] VGND VGND VPWR VPWR u_mem._0252_ sky130_fd_sc_hd__clkbuf_4
Xu_mem._1088_ wr_clk u_mem._0116_ VGND VGND VPWR VPWR u_mem.mem\[0\]\[4\] sky130_fd_sc_hd__dfxtp_1
XFILLER_0_30_115 VGND VGND VPWR VPWR sky130_fd_sc_hd__decap_3
XFILLER_0_38_226 VPWR VGND VPWR VGND sky130_ef_sc_hd__decap_12
XFILLER_0_21_148 VPWR VGND VPWR VGND sky130_ef_sc_hd__decap_12
Xu_mem._1011_ wr_clk u_mem._0039_ VGND VGND VPWR VPWR u_mem.mem\[13\]\[7\] sky130_fd_sc_hd__dfxtp_1
XFILLER_0_12_148 VGND VGND VPWR VPWR sky130_fd_sc_hd__decap_8
Xu_mem._0657_ u_mem.rd_addr\[1\] VGND VGND VPWR VPWR u_mem._0235_ sky130_fd_sc_hd__clkbuf_4
Xu_mem._0726_ u_mem._0247_ u_mem._0301_ VGND VGND VPWR VPWR u_mem._0302_ sky130_fd_sc_hd__or2b_1
Xu_mem._0588_ u_mem._0197_ VGND VGND VPWR VPWR u_mem._0040_ sky130_fd_sc_hd__clkbuf_1
XFILLER_0_7_131 VGND VGND VPWR VPWR sky130_fd_sc_hd__decap_4
Xoutput15 net15 VGND VGND VPWR VPWR dout[3] sky130_fd_sc_hd__clkbuf_1
XTAP_129 VGND VPWR sky130_fd_sc_hd__tapvpwrvgnd_1
XTAP_118 VGND VPWR sky130_fd_sc_hd__tapvpwrvgnd_1
XTAP_107 VGND VPWR sky130_fd_sc_hd__tapvpwrvgnd_1
Xu_mem._0511_ u_mem.mem\[3\]\[7\] u_mem._0153_ u_mem._0139_ VGND VGND VPWR VPWR u_mem._0154_
+ sky130_fd_sc_hd__mux2_1
XPHY_1 VGND VGND VPWR VPWR sky130_fd_sc_hd__decap_3
XFILLER_0_4_156 VGND VGND VPWR VPWR sky130_fd_sc_hd__fill_1
XFILLER_0_4_134 VGND VGND VPWR VPWR sky130_fd_sc_hd__decap_3
XFILLER_0_40_265 VGND VGND VPWR VPWR sky130_fd_sc_hd__decap_4
XFILLER_0_7_66 VGND VGND VPWR VPWR sky130_fd_sc_hd__decap_8
XFILLER_0_7_22 VGND VGND VPWR VPWR sky130_fd_sc_hd__decap_4
Xu_mem._0709_ u_mem._0236_ u_mem._0285_ VGND VGND VPWR VPWR u_mem._0286_ sky130_fd_sc_hd__nand2_1
XFILLER_0_30_3 VGND VGND VPWR VPWR sky130_fd_sc_hd__decap_3
XFILLER_0_16_251 VGND VGND VPWR VPWR sky130_fd_sc_hd__fill_1
XFILLER_0_1_104 VGND VGND VPWR VPWR sky130_fd_sc_hd__decap_3
Xu_mem._0991_ wr_clk u_mem._0019_ VGND VGND VPWR VPWR u_mem.mem\[12\]\[3\] sky130_fd_sc_hd__dfxtp_1
XFILLER_0_22_265 VGND VGND VPWR VPWR sky130_fd_sc_hd__decap_4
XFILLER_0_6_207 VPWR VGND VPWR VGND sky130_ef_sc_hd__decap_12
XFILLER_0_24_46 VGND VGND VPWR VPWR sky130_fd_sc_hd__fill_2
Xu_mem._0974_ wr_clk u_mem._0002_ VGND VGND VPWR VPWR u_mem.mem\[3\]\[2\] sky130_fd_sc_hd__dfxtp_1
XFILLER_0_45_165 VGND VGND VPWR VPWR sky130_fd_sc_hd__decap_3
Xu_read._70_ u_read.rd_ptr_bin\[4\] u_read._31_ VGND VGND VPWR VPWR u_read._32_ sky130_fd_sc_hd__xnor2_1
XTAP_290 VGND VPWR sky130_fd_sc_hd__tapvpwrvgnd_1
XFILLER_0_36_132 VGND VGND VPWR VPWR sky130_fd_sc_hd__decap_8
Xu_write._79_ u_mem.wr_addr\[2\] u_write._29_ VGND VGND VPWR VPWR u_write._39_ sky130_fd_sc_hd__nor2_1
Xu_mem._0690_ u_mem._0265_ u_mem._0267_ VGND VGND VPWR VPWR u_mem._0268_ sky130_fd_sc_hd__or2b_1
XFILLER_0_19_13 VGND VGND VPWR VPWR sky130_fd_sc_hd__fill_1
XFILLER_0_19_35 VGND VGND VPWR VPWR sky130_fd_sc_hd__decap_6
XFILLER_0_19_57 VGND VGND VPWR VPWR sky130_fd_sc_hd__decap_4
XFILLER_0_42_157 VGND VGND VPWR VPWR sky130_fd_sc_hd__fill_1
XFILLER_0_2_265 VGND VGND VPWR VPWR sky130_fd_sc_hd__decap_4
XFILLER_0_2_232 VPWR VGND VPWR VGND sky130_ef_sc_hd__decap_12
Xu_mem._0957_ u_mem._0478_ VGND VGND VPWR VPWR u_mem._0128_ sky130_fd_sc_hd__clkbuf_1
Xu_mem._0888_ u_mem._0136_ u_mem.mem\[15\]\[0\] u_mem._0441_ VGND VGND VPWR VPWR u_mem._0442_
+ sky130_fd_sc_hd__mux2_1
XFILLER_0_18_165 VGND VGND VPWR VPWR sky130_fd_sc_hd__decap_3
Xu_read._53_ u_read._09_ u_read._14_ u_read._18_ VGND VGND VPWR VPWR net20 sky130_fd_sc_hd__nor3_1
XFILLER_0_21_69 VGND VGND VPWR VPWR sky130_fd_sc_hd__fill_2
XFILLER_0_24_135 VGND VGND VPWR VPWR sky130_fd_sc_hd__fill_2
Xu_mem._0742_ u_mem.mem\[14\]\[3\] u_mem.mem\[15\]\[3\] u_mem._0237_ VGND VGND VPWR
+ VPWR u_mem._0317_ sky130_fd_sc_hd__mux2_1
Xu_mem._0673_ u_mem._0235_ VGND VGND VPWR VPWR u_mem._0251_ sky130_fd_sc_hd__clkbuf_4
Xu_mem._0811_ u_mem.mem\[13\]\[6\] u_mem._0266_ VGND VGND VPWR VPWR u_mem._0383_ sky130_fd_sc_hd__and2b_1
XFILLER_0_1_57 VPWR VGND VPWR VGND sky130_ef_sc_hd__decap_12
XFILLER_0_15_113 VGND VGND VPWR VPWR sky130_fd_sc_hd__fill_2
XFILLER_0_15_146 VGND VGND VPWR VPWR sky130_fd_sc_hd__fill_1
Xu_mem._1087_ wr_clk u_mem._0115_ VGND VGND VPWR VPWR u_mem.mem\[0\]\[3\] sky130_fd_sc_hd__dfxtp_1
XFILLER_0_38_238 VGND VGND VPWR VPWR sky130_fd_sc_hd__fill_2
Xu_mem._1010_ wr_clk u_mem._0038_ VGND VGND VPWR VPWR u_mem.mem\[13\]\[6\] sky130_fd_sc_hd__dfxtp_1
Xu_mem._0725_ u_mem.mem\[8\]\[2\] u_mem.mem\[9\]\[2\] u_mem._0248_ VGND VGND VPWR
+ VPWR u_mem._0301_ sky130_fd_sc_hd__mux2_1
Xu_mem._0656_ u_mem._0233_ VGND VGND VPWR VPWR u_mem._0234_ sky130_fd_sc_hd__clkbuf_4
Xu_mem._0587_ u_mem.mem\[2\]\[0\] u_mem._0136_ u_mem._0196_ VGND VGND VPWR VPWR u_mem._0197_
+ sky130_fd_sc_hd__mux2_1
XFILLER_0_7_110 VGND VGND VPWR VPWR sky130_fd_sc_hd__fill_2
XFILLER_0_43_241 VGND VGND VPWR VPWR sky130_fd_sc_hd__fill_2
XFILLER_0_7_176 VGND VGND VPWR VPWR sky130_fd_sc_hd__decap_4
XFILLER_0_7_143 VGND VGND VPWR VPWR sky130_fd_sc_hd__decap_8
Xoutput16 net16 VGND VGND VPWR VPWR dout[4] sky130_fd_sc_hd__clkbuf_1
XFILLER_0_34_241 VGND VGND VPWR VPWR sky130_fd_sc_hd__decap_3
XFILLER_0_26_219 VGND VGND VPWR VPWR sky130_fd_sc_hd__fill_1
XTAP_119 VGND VPWR sky130_fd_sc_hd__tapvpwrvgnd_1
XTAP_108 VGND VPWR sky130_fd_sc_hd__tapvpwrvgnd_1
Xu_mem._0510_ net8 VGND VGND VPWR VPWR u_mem._0153_ sky130_fd_sc_hd__buf_2
XPHY_2 VGND VGND VPWR VPWR sky130_fd_sc_hd__decap_3
XFILLER_0_25_241 VGND VGND VPWR VPWR sky130_fd_sc_hd__fill_1
Xu_mem._0639_ u_mem._0224_ VGND VGND VPWR VPWR u_mem._0064_ sky130_fd_sc_hd__clkbuf_1
Xu_mem._0708_ u_mem.mem\[6\]\[1\] u_mem.mem\[7\]\[1\] u_mem._0258_ VGND VGND VPWR
+ VPWR u_mem._0285_ sky130_fd_sc_hd__mux2_1
XFILLER_0_23_3 VGND VGND VPWR VPWR sky130_fd_sc_hd__decap_8
XFILLER_0_31_222 VGND VGND VPWR VPWR sky130_fd_sc_hd__fill_2
XFILLER_0_31_266 VGND VGND VPWR VPWR sky130_fd_sc_hd__fill_1
Xu_mem._0990_ wr_clk u_mem._0018_ VGND VGND VPWR VPWR u_mem.mem\[12\]\[2\] sky130_fd_sc_hd__dfxtp_1
XFILLER_0_1_149 VPWR VGND VPWR VGND sky130_ef_sc_hd__decap_12
XFILLER_0_13_222 VGND VGND VPWR VPWR sky130_fd_sc_hd__fill_2
XFILLER_0_6_219 VGND VGND VPWR VPWR sky130_fd_sc_hd__fill_2
XFILLER_0_40_68 VGND VGND VPWR VPWR sky130_fd_sc_hd__fill_1
Xu_mem._0973_ wr_clk u_mem._0001_ VGND VGND VPWR VPWR u_mem.mem\[3\]\[1\] sky130_fd_sc_hd__dfxtp_1
XFILLER_0_10_269 VGND VGND VPWR VPWR sky130_fd_sc_hd__fill_1
XFILLER_0_14_80 VGND VGND VPWR VPWR sky130_fd_sc_hd__decap_4
XTAP_291 VGND VPWR sky130_fd_sc_hd__tapvpwrvgnd_1
XTAP_280 VGND VPWR sky130_fd_sc_hd__tapvpwrvgnd_1
XFILLER_0_36_144 VPWR VGND VPWR VGND sky130_ef_sc_hd__decap_12
XFILLER_0_36_188 VGND VGND VPWR VPWR sky130_fd_sc_hd__fill_1
Xu_write._78_ u_write._20_ u_write._30_ u_write._38_ net10 VGND VGND VPWR VPWR u_write._06_
+ sky130_fd_sc_hd__a211oi_1
XFILLER_0_35_57 VGND VGND VPWR VPWR sky130_fd_sc_hd__fill_1
XFILLER_0_27_111 VGND VGND VPWR VPWR sky130_fd_sc_hd__fill_1
XFILLER_0_27_166 VGND VGND VPWR VPWR sky130_fd_sc_hd__fill_2
Xu_mem._0956_ u_mem.mem\[9\]\[0\] net1 u_mem._0477_ VGND VGND VPWR VPWR u_mem._0478_
+ sky130_fd_sc_hd__mux2_1
XFILLER_0_2_244 VGND VGND VPWR VPWR sky130_fd_sc_hd__decap_8
Xu_mem._0887_ u_mem._0138_ u_mem._0166_ VGND VGND VPWR VPWR u_mem._0441_ sky130_fd_sc_hd__nand2b_4
XFILLER_0_18_122 VGND VGND VPWR VPWR sky130_fd_sc_hd__decap_8
Xu_read._52_ u_read.rd_ptr_gray\[0\] u_read._10_ u_read._15_ u_read._16_ u_read._17_
+ VGND VGND VPWR VPWR u_read._18_ sky130_fd_sc_hd__o2111ai_2
XFILLER_0_18_177 VPWR VGND VPWR VGND sky130_ef_sc_hd__decap_12
XFILLER_0_33_147 VGND VGND VPWR VPWR sky130_fd_sc_hd__fill_2
XFILLER_0_24_114 VGND VGND VPWR VPWR sky130_fd_sc_hd__fill_2
Xu_mem._0810_ u_mem._0258_ u_mem.mem\[12\]\[6\] VGND VGND VPWR VPWR u_mem._0382_ sky130_fd_sc_hd__nor2_1
Xu_mem._0672_ u_mem._0247_ u_mem._0249_ VGND VGND VPWR VPWR u_mem._0250_ sky130_fd_sc_hd__or2b_1
Xu_mem._0741_ u_mem._0234_ u_mem._0305_ u_mem._0315_ u_mem._0316_ VGND VGND VPWR VPWR
+ u_mem._0074_ sky130_fd_sc_hd__a31oi_1
XFILLER_0_1_69 VGND VGND VPWR VPWR sky130_fd_sc_hd__decap_6
Xu_mem._1086_ wr_clk u_mem._0114_ VGND VGND VPWR VPWR u_mem.mem\[0\]\[2\] sky130_fd_sc_hd__dfxtp_1
Xu_mem._0939_ u_mem.mem\[5\]\[0\] net1 u_mem._0468_ VGND VGND VPWR VPWR u_mem._0469_
+ sky130_fd_sc_hd__mux2_1
XFILLER_0_16_59 VGND VGND VPWR VPWR sky130_fd_sc_hd__fill_1
XFILLER_0_29_239 VPWR VGND VPWR VGND sky130_ef_sc_hd__decap_12
XFILLER_0_32_25 VGND VGND VPWR VPWR sky130_fd_sc_hd__decap_3
XFILLER_0_12_106 VGND VGND VPWR VPWR sky130_fd_sc_hd__decap_6
Xu_mem._0655_ u_mem._0232_ VGND VGND VPWR VPWR u_mem._0233_ sky130_fd_sc_hd__buf_2
Xu_mem._0724_ u_mem._0240_ u_mem._0298_ u_mem._0299_ u_mem._0245_ VGND VGND VPWR VPWR
+ u_mem._0300_ sky130_fd_sc_hd__o31a_1
Xu_mem._0586_ u_mem._0137_ u_mem._0195_ VGND VGND VPWR VPWR u_mem._0196_ sky130_fd_sc_hd__nor2_4
XFILLER_0_28_250 VGND VGND VPWR VPWR sky130_fd_sc_hd__fill_2
Xu_mem._1069_ wr_clk u_mem._0097_ VGND VGND VPWR VPWR u_mem.mem\[15\]\[1\] sky130_fd_sc_hd__dfxtp_1
Xoutput17 net17 VGND VGND VPWR VPWR dout[5] sky130_fd_sc_hd__buf_1
XFILLER_0_11_161 VGND VGND VPWR VPWR sky130_fd_sc_hd__decap_6
XTAP_109 VGND VPWR sky130_fd_sc_hd__tapvpwrvgnd_1
XPHY_3 VGND VGND VPWR VPWR sky130_fd_sc_hd__decap_3
XFILLER_0_25_264 VGND VGND VPWR VPWR sky130_fd_sc_hd__decap_6
Xu_mem._0707_ u_mem._0276_ u_mem._0279_ u_mem._0281_ u_mem._0283_ u_mem._0256_ VGND
+ VGND VPWR VPWR u_mem._0284_ sky130_fd_sc_hd__a221o_1
Xu_mem._0569_ u_mem._0136_ u_mem.mem\[13\]\[0\] u_mem._0186_ VGND VGND VPWR VPWR u_mem._0187_
+ sky130_fd_sc_hd__mux2_1
Xu_mem._0638_ u_mem.mem\[11\]\[0\] net1 u_mem._0223_ VGND VGND VPWR VPWR u_mem._0224_
+ sky130_fd_sc_hd__mux2_1
XFILLER_0_16_3 VGND VGND VPWR VPWR sky130_fd_sc_hd__decap_4
XFILLER_0_16_231 VPWR VGND VPWR VGND sky130_ef_sc_hd__decap_12
XFILLER_0_16_253 VPWR VGND VPWR VGND sky130_ef_sc_hd__decap_12
XFILLER_0_13_234 VGND VGND VPWR VPWR sky130_fd_sc_hd__decap_6
XFILLER_0_13_256 VPWR VGND VPWR VGND sky130_ef_sc_hd__decap_12
XFILLER_0_5_3 VPWR VGND VPWR VGND sky130_ef_sc_hd__decap_12
Xu_mem._0972_ wr_clk u_mem._0000_ VGND VGND VPWR VPWR u_mem.mem\[3\]\[0\] sky130_fd_sc_hd__dfxtp_1
XFILLER_0_10_215 VPWR VGND VPWR VGND sky130_ef_sc_hd__decap_12
XTAP_292 VGND VPWR sky130_fd_sc_hd__tapvpwrvgnd_1
XTAP_281 VGND VPWR sky130_fd_sc_hd__tapvpwrvgnd_1
XTAP_270 VGND VPWR sky130_fd_sc_hd__tapvpwrvgnd_1
XFILLER_0_36_156 VGND VGND VPWR VPWR sky130_fd_sc_hd__fill_2
Xu_write._77_ u_mem.wr_addr\[1\] u_write._29_ VGND VGND VPWR VPWR u_write._38_ sky130_fd_sc_hd__nor2_1
XFILLER_0_27_178 VGND VGND VPWR VPWR sky130_fd_sc_hd__decap_6
XFILLER_0_27_189 VGND VGND VPWR VPWR sky130_fd_sc_hd__fill_2
Xu_mem._0955_ u_mem._0176_ u_mem._0422_ VGND VGND VPWR VPWR u_mem._0477_ sky130_fd_sc_hd__nor2_4
Xu_mem._0886_ u_mem._0440_ VGND VGND VPWR VPWR u_mem._0095_ sky130_fd_sc_hd__clkbuf_1
Xu_read._51_ u_read.wr_gray_sync2\[2\] u_read.rd_ptr_gray\[2\] VGND VGND VPWR VPWR
+ u_read._17_ sky130_fd_sc_hd__or2b_1
XFILLER_0_18_189 VGND VGND VPWR VPWR sky130_fd_sc_hd__decap_6
Xu_mem._0740_ u_mem.dout\[2\] u_mem._0233_ VGND VGND VPWR VPWR u_mem._0316_ sky130_fd_sc_hd__nor2_1
XFILLER_0_32_170 VGND VGND VPWR VPWR sky130_fd_sc_hd__fill_1
Xu_mem._0671_ u_mem.mem\[8\]\[0\] u_mem.mem\[9\]\[0\] u_mem._0248_ VGND VGND VPWR
+ VPWR u_mem._0249_ sky130_fd_sc_hd__mux2_1
XFILLER_0_1_15 VPWR VGND VPWR VGND sky130_ef_sc_hd__decap_12
Xu_mem._1085_ wr_clk u_mem._0113_ VGND VGND VPWR VPWR u_mem.mem\[0\]\[1\] sky130_fd_sc_hd__dfxtp_1
Xu_mem._0869_ u_mem._0431_ VGND VGND VPWR VPWR u_mem._0087_ sky130_fd_sc_hd__clkbuf_1
Xu_mem._0938_ u_mem._0155_ u_mem._0422_ VGND VGND VPWR VPWR u_mem._0468_ sky130_fd_sc_hd__nor2_4
XFILLER_0_16_27 VGND VGND VPWR VPWR sky130_fd_sc_hd__fill_1
XFILLER_0_29_207 VGND VGND VPWR VPWR sky130_fd_sc_hd__decap_4
XFILLER_0_32_15 VGND VGND VPWR VPWR sky130_fd_sc_hd__fill_1
Xu_mem._0723_ u_mem.mem\[13\]\[2\] u_mem._0243_ VGND VGND VPWR VPWR u_mem._0299_ sky130_fd_sc_hd__and2b_1
Xu_mem._0654_ net20 net9 VGND VGND VPWR VPWR u_mem._0232_ sky130_fd_sc_hd__and2b_1
Xu_mem._0585_ u_mem.wr_addr\[0\] u_mem.wr_addr\[1\] VGND VGND VPWR VPWR u_mem._0195_
+ sky130_fd_sc_hd__or2b_4
Xu_mem._1068_ wr_clk u_mem._0096_ VGND VGND VPWR VPWR u_mem.mem\[15\]\[0\] sky130_fd_sc_hd__dfxtp_1
Xoutput18 net18 VGND VGND VPWR VPWR dout[6] sky130_fd_sc_hd__clkbuf_1
XFILLER_0_4_115 VGND VGND VPWR VPWR sky130_fd_sc_hd__fill_1
XPHY_4 VGND VGND VPWR VPWR sky130_fd_sc_hd__decap_3
Xu_mem._0706_ u_mem._0251_ u_mem._0282_ u_mem._0254_ VGND VGND VPWR VPWR u_mem._0283_
+ sky130_fd_sc_hd__a21oi_1
Xu_mem._0637_ u_mem._0138_ u_mem._0176_ VGND VGND VPWR VPWR u_mem._0223_ sky130_fd_sc_hd__nor2_4
Xu_mem._0499_ u_mem.mem\[3\]\[3\] u_mem._0145_ u_mem._0139_ VGND VGND VPWR VPWR u_mem._0146_
+ sky130_fd_sc_hd__mux2_1
Xu_mem._0568_ u_mem.wr_addr\[1\] u_mem._0166_ u_mem.wr_addr\[0\] VGND VGND VPWR VPWR
+ u_mem._0186_ sky130_fd_sc_hd__nand3b_4
XFILLER_0_16_243 VGND VGND VPWR VPWR sky130_fd_sc_hd__decap_8
XFILLER_0_16_265 VGND VGND VPWR VPWR sky130_fd_sc_hd__fill_2
XFILLER_0_3_192 VGND VGND VPWR VPWR sky130_fd_sc_hd__decap_6
XFILLER_0_1_129 VGND VGND VPWR VPWR sky130_fd_sc_hd__fill_1
XFILLER_0_22_213 VPWR VGND VPWR VGND sky130_ef_sc_hd__decap_12
XFILLER_0_13_202 VGND VGND VPWR VPWR sky130_fd_sc_hd__decap_8
XFILLER_0_0_195 VGND VGND VPWR VPWR sky130_fd_sc_hd__fill_1
XFILLER_0_13_268 VGND VGND VPWR VPWR sky130_fd_sc_hd__fill_2
XFILLER_0_39_132 VGND VGND VPWR VPWR sky130_fd_sc_hd__fill_2
XFILLER_0_24_27 VGND VGND VPWR VPWR sky130_fd_sc_hd__fill_1
XFILLER_0_39_165 VGND VGND VPWR VPWR sky130_fd_sc_hd__decap_3
XFILLER_0_40_15 VPWR VGND VPWR VGND sky130_ef_sc_hd__decap_12
XFILLER_0_4_15 VPWR VGND VPWR VGND sky130_ef_sc_hd__decap_12
XFILLER_0_10_227 VPWR VGND VPWR VGND sky130_ef_sc_hd__decap_12
Xu_mem._0971_ u_mem._0485_ VGND VGND VPWR VPWR u_mem._0135_ sky130_fd_sc_hd__clkbuf_1
XFILLER_0_45_113 VGND VGND VPWR VPWR sky130_fd_sc_hd__fill_1
XFILLER_0_5_210 VPWR VGND VPWR VGND sky130_ef_sc_hd__decap_12
XTAP_293 VGND VPWR sky130_fd_sc_hd__tapvpwrvgnd_1
XTAP_282 VGND VPWR sky130_fd_sc_hd__tapvpwrvgnd_1
XTAP_271 VGND VPWR sky130_fd_sc_hd__tapvpwrvgnd_1
XTAP_260 VGND VPWR sky130_fd_sc_hd__tapvpwrvgnd_1
Xu_write._76_ u_mem.wr_addr\[0\] u_write._30_ u_write._37_ VGND VGND VPWR VPWR u_write._05_
+ sky130_fd_sc_hd__a21oi_1
XFILLER_0_10_29 VPWR VGND VPWR VGND sky130_ef_sc_hd__decap_12
XFILLER_0_27_113 VPWR VGND VPWR VGND sky130_ef_sc_hd__decap_12
XFILLER_0_42_127 VGND VGND VPWR VPWR sky130_fd_sc_hd__decap_3
XFILLER_0_42_105 VGND VGND VPWR VPWR sky130_fd_sc_hd__fill_1
Xu_mem._0885_ u_mem._0153_ u_mem.mem\[14\]\[7\] u_mem._0432_ VGND VGND VPWR VPWR u_mem._0440_
+ sky130_fd_sc_hd__mux2_1
Xu_mem._0954_ u_mem._0476_ VGND VGND VPWR VPWR u_mem._0127_ sky130_fd_sc_hd__clkbuf_1
Xu_read._50_ u_read.wr_gray_sync2\[1\] u_read.rd_ptr_gray\[1\] VGND VGND VPWR VPWR
+ u_read._16_ sky130_fd_sc_hd__or2b_1
Xu_write._59_ u_sync_rd2wr.gray_sync2\[4\] u_write._12_ VGND VGND VPWR VPWR u_write._27_
+ sky130_fd_sc_hd__xnor2_1
Xu_mem._0670_ u_mem.rd_addr\[0\] VGND VGND VPWR VPWR u_mem._0248_ sky130_fd_sc_hd__buf_4
XFILLER_0_1_27 VPWR VGND VPWR VGND sky130_ef_sc_hd__decap_12
Xu_mem._1084_ wr_clk u_mem._0112_ VGND VGND VPWR VPWR u_mem.mem\[0\]\[0\] sky130_fd_sc_hd__dfxtp_1
XFILLER_0_15_105 VGND VGND VPWR VPWR sky130_fd_sc_hd__decap_3
XFILLER_0_30_108 VGND VGND VPWR VPWR sky130_fd_sc_hd__fill_1
Xu_mem._0937_ u_mem._0467_ VGND VGND VPWR VPWR u_mem._0119_ sky130_fd_sc_hd__clkbuf_1
Xu_mem._0799_ u_mem.mem\[5\]\[5\] u_mem._0243_ VGND VGND VPWR VPWR u_mem._0372_ sky130_fd_sc_hd__and2b_1
Xu_mem._0868_ u_mem.mem\[1\]\[7\] net8 u_mem._0423_ VGND VGND VPWR VPWR u_mem._0431_
+ sky130_fd_sc_hd__mux2_1
Xu_mem._0722_ u_mem._0258_ u_mem.mem\[12\]\[2\] VGND VGND VPWR VPWR u_mem._0298_ sky130_fd_sc_hd__nor2_1
Xu_mem._0653_ u_mem._0231_ VGND VGND VPWR VPWR u_mem._0071_ sky130_fd_sc_hd__clkbuf_1
Xu_mem._0584_ u_mem._0194_ VGND VGND VPWR VPWR u_mem._0039_ sky130_fd_sc_hd__clkbuf_1
Xu_mem._1067_ wr_clk u_mem._0095_ VGND VGND VPWR VPWR u_mem.mem\[14\]\[7\] sky130_fd_sc_hd__dfxtp_1
Xoutput19 net19 VGND VGND VPWR VPWR dout[7] sky130_fd_sc_hd__buf_1
Xu_sync_wr2rd._39_ u_sync_wr2rd._19_ VGND VGND VPWR VPWR u_sync_wr2rd._09_ sky130_fd_sc_hd__clkbuf_1
XFILLER_0_27_16 VPWR VGND VPWR VGND sky130_ef_sc_hd__decap_12
XFILLER_0_43_15 VPWR VGND VPWR VGND sky130_ef_sc_hd__decap_12
XPHY_5 VGND VGND VPWR VPWR sky130_fd_sc_hd__decap_3
XFILLER_0_40_269 VGND VGND VPWR VPWR sky130_fd_sc_hd__fill_1
XFILLER_0_40_203 VPWR VGND VPWR VGND sky130_ef_sc_hd__decap_12
XFILLER_0_7_26 VGND VGND VPWR VPWR sky130_fd_sc_hd__fill_1
Xu_mem._0705_ u_mem.mem\[10\]\[1\] u_mem.mem\[11\]\[1\] u_mem._0252_ VGND VGND VPWR
+ VPWR u_mem._0282_ sky130_fd_sc_hd__mux2_1
Xu_mem._0636_ u_mem._0222_ VGND VGND VPWR VPWR u_mem._0063_ sky130_fd_sc_hd__clkbuf_1
Xu_mem._0498_ net4 VGND VGND VPWR VPWR u_mem._0145_ sky130_fd_sc_hd__buf_2
Xu_mem._0567_ u_mem._0185_ VGND VGND VPWR VPWR u_mem._0031_ sky130_fd_sc_hd__clkbuf_1
XFILLER_0_31_225 VPWR VGND VPWR VGND sky130_ef_sc_hd__decap_12
XFILLER_0_38_15 VPWR VGND VPWR VGND sky130_ef_sc_hd__decap_12
XFILLER_0_22_225 VGND VGND VPWR VPWR sky130_fd_sc_hd__fill_2
XFILLER_0_22_269 VGND VGND VPWR VPWR sky130_fd_sc_hd__fill_1
XFILLER_0_38_37 VGND VGND VPWR VPWR sky130_fd_sc_hd__fill_2
XFILLER_0_9_219 VGND VGND VPWR VPWR sky130_fd_sc_hd__fill_2
XFILLER_0_0_141 VPWR VGND VPWR VGND sky130_ef_sc_hd__decap_12
XFILLER_0_21_3 VGND VGND VPWR VPWR sky130_fd_sc_hd__fill_2
Xu_mem._0619_ u_mem._0213_ VGND VGND VPWR VPWR u_mem._0055_ sky130_fd_sc_hd__clkbuf_1
XFILLER_0_44_91 VPWR VGND VPWR VGND sky130_ef_sc_hd__decap_12
Xu_write._92_ u_write.wr_ptr_bin\[4\] VGND VGND VPWR VPWR u_sync_wr2rd.gray_in\[4\]
+ sky130_fd_sc_hd__clkbuf_1
XFILLER_0_39_188 VPWR VGND VPWR VGND sky130_ef_sc_hd__decap_12
XFILLER_0_40_27 VGND VGND VPWR VPWR sky130_fd_sc_hd__fill_1
XFILLER_0_4_27 VGND VGND VPWR VPWR sky130_fd_sc_hd__fill_1
XFILLER_0_10_239 VPWR VGND VPWR VGND sky130_ef_sc_hd__decap_12
Xu_mem._0970_ u_mem.mem\[9\]\[7\] net8 u_mem._0477_ VGND VGND VPWR VPWR u_mem._0485_
+ sky130_fd_sc_hd__mux2_1
XFILLER_0_45_169 VPWR VGND VPWR VGND sky130_ef_sc_hd__decap_12
XFILLER_0_5_222 VGND VGND VPWR VPWR sky130_fd_sc_hd__fill_2
XTAP_294 VGND VPWR sky130_fd_sc_hd__tapvpwrvgnd_1
XTAP_283 VGND VPWR sky130_fd_sc_hd__tapvpwrvgnd_1
XFILLER_0_39_80 VGND VGND VPWR VPWR sky130_fd_sc_hd__decap_3
XTAP_272 VGND VPWR sky130_fd_sc_hd__tapvpwrvgnd_1
XTAP_261 VGND VPWR sky130_fd_sc_hd__tapvpwrvgnd_1
XTAP_250 VGND VPWR sky130_fd_sc_hd__tapvpwrvgnd_1
Xu_write._75_ u_mem.wr_addr\[0\] u_write._30_ net10 VGND VGND VPWR VPWR u_write._37_
+ sky130_fd_sc_hd__o21bai_1
XFILLER_0_35_49 VGND VGND VPWR VPWR sky130_fd_sc_hd__decap_6
XFILLER_0_27_103 VGND VGND VPWR VPWR sky130_fd_sc_hd__decap_8
XFILLER_0_27_125 VGND VGND VPWR VPWR sky130_fd_sc_hd__fill_2
XFILLER_0_27_158 VGND VGND VPWR VPWR sky130_fd_sc_hd__fill_2
XFILLER_0_42_139 VGND VGND VPWR VPWR sky130_fd_sc_hd__fill_1
XFILLER_0_2_269 VGND VGND VPWR VPWR sky130_fd_sc_hd__fill_1
XFILLER_0_2_203 VGND VGND VPWR VPWR sky130_fd_sc_hd__fill_1
Xu_mem._0953_ u_mem.mem\[5\]\[7\] net8 u_mem._0468_ VGND VGND VPWR VPWR u_mem._0476_
+ sky130_fd_sc_hd__mux2_1
Xu_mem._0884_ u_mem._0439_ VGND VGND VPWR VPWR u_mem._0094_ sky130_fd_sc_hd__clkbuf_1
XFILLER_0_18_136 VGND VGND VPWR VPWR sky130_fd_sc_hd__fill_1
Xu_write._58_ u_mem.wr_addr\[1\] u_sync_rd2wr.gray_sync2\[0\] VGND VGND VPWR VPWR
+ u_write._26_ sky130_fd_sc_hd__or2_1
XFILLER_0_1_39 VPWR VGND VPWR VGND sky130_ef_sc_hd__decap_12
Xu_mem._1083_ wr_clk u_mem._0111_ VGND VGND VPWR VPWR u_mem.mem\[10\]\[7\] sky130_fd_sc_hd__dfxtp_1
XFILLER_0_11_73 VGND VGND VPWR VPWR sky130_fd_sc_hd__fill_1
XFILLER_0_23_150 VGND VGND VPWR VPWR sky130_fd_sc_hd__decap_6
Xu_mem._0936_ u_mem.mem\[0\]\[7\] net8 u_mem._0459_ VGND VGND VPWR VPWR u_mem._0467_
+ sky130_fd_sc_hd__mux2_1
Xu_mem._0867_ u_mem._0430_ VGND VGND VPWR VPWR u_mem._0086_ sky130_fd_sc_hd__clkbuf_1
XFILLER_0_36_81 VGND VGND VPWR VPWR sky130_fd_sc_hd__decap_3
Xu_mem._0798_ u_mem._0241_ u_mem.mem\[4\]\[5\] VGND VGND VPWR VPWR u_mem._0371_ sky130_fd_sc_hd__nor2_1
XFILLER_0_14_150 VGND VGND VPWR VPWR sky130_fd_sc_hd__fill_2
XFILLER_0_16_29 VPWR VGND VPWR VGND sky130_ef_sc_hd__decap_12
XFILLER_0_32_39 VPWR VGND VPWR VGND sky130_ef_sc_hd__decap_12
Xu_mem._0721_ u_mem._0269_ u_mem._0296_ VGND VGND VPWR VPWR u_mem._0297_ sky130_fd_sc_hd__nand2_1
Xu_mem._0652_ u_mem.mem\[11\]\[7\] net8 u_mem._0223_ VGND VGND VPWR VPWR u_mem._0231_
+ sky130_fd_sc_hd__mux2_1
Xu_mem._0583_ u_mem._0153_ u_mem.mem\[13\]\[7\] u_mem._0186_ VGND VGND VPWR VPWR u_mem._0194_
+ sky130_fd_sc_hd__mux2_1
XFILLER_0_7_103 VGND VGND VPWR VPWR sky130_fd_sc_hd__decap_4
XFILLER_0_18_9 VGND VGND VPWR VPWR sky130_fd_sc_hd__fill_1
XFILLER_0_43_201 VGND VGND VPWR VPWR sky130_fd_sc_hd__fill_1
Xu_mem._1066_ wr_clk u_mem._0094_ VGND VGND VPWR VPWR u_mem.mem\[14\]\[6\] sky130_fd_sc_hd__dfxtp_1
XFILLER_0_22_61 VGND VGND VPWR VPWR sky130_fd_sc_hd__decap_8
XFILLER_0_28_253 VPWR VGND VPWR VGND sky130_ef_sc_hd__decap_12
XFILLER_0_11_175 VGND VGND VPWR VPWR sky130_fd_sc_hd__fill_1
Xu_mem._0919_ u_mem.mem\[10\]\[7\] net8 u_mem._0450_ VGND VGND VPWR VPWR u_mem._0458_
+ sky130_fd_sc_hd__mux2_1
XFILLER_0_19_220 VGND VGND VPWR VPWR sky130_fd_sc_hd__fill_1
XFILLER_0_19_242 VPWR VGND VPWR VGND sky130_ef_sc_hd__decap_12
Xu_sync_wr2rd._38_ net10 u_sync_wr2rd.gray_in\[4\] VGND VGND VPWR VPWR u_sync_wr2rd._19_
+ sky130_fd_sc_hd__and2b_1
XFILLER_0_27_28 VPWR VGND VPWR VGND sky130_ef_sc_hd__decap_12
XFILLER_0_43_27 VGND VGND VPWR VPWR sky130_fd_sc_hd__decap_8
XPHY_6 VGND VGND VPWR VPWR sky130_fd_sc_hd__decap_3
XFILLER_0_40_215 VPWR VGND VPWR VGND sky130_ef_sc_hd__decap_12
Xu_mem._0566_ u_mem.mem\[8\]\[7\] u_mem._0153_ u_mem._0177_ VGND VGND VPWR VPWR u_mem._0185_
+ sky130_fd_sc_hd__mux2_1
Xu_mem._0704_ u_mem._0247_ u_mem._0280_ VGND VGND VPWR VPWR u_mem._0281_ sky130_fd_sc_hd__or2b_1
Xu_mem._0635_ u_mem.mem\[6\]\[7\] u_mem._0153_ u_mem._0214_ VGND VGND VPWR VPWR u_mem._0222_
+ sky130_fd_sc_hd__mux2_1
Xu_mem._0497_ u_mem._0144_ VGND VGND VPWR VPWR u_mem._0002_ sky130_fd_sc_hd__clkbuf_1
XFILLER_0_33_82 VGND VGND VPWR VPWR sky130_fd_sc_hd__fill_2
Xu_mem._1049_ rd_clk u_mem._0077_ VGND VGND VPWR VPWR u_mem.dout\[5\] sky130_fd_sc_hd__dfxtp_1
XFILLER_0_31_237 VGND VGND VPWR VPWR sky130_fd_sc_hd__decap_4
XFILLER_0_38_49 VGND VGND VPWR VPWR sky130_fd_sc_hd__decap_8
XFILLER_0_38_27 VGND VGND VPWR VPWR sky130_fd_sc_hd__fill_1
XFILLER_0_0_153 VPWR VGND VPWR VGND sky130_ef_sc_hd__decap_12
XFILLER_0_0_197 VPWR VGND VPWR VGND sky130_ef_sc_hd__decap_12
XFILLER_0_14_3 VGND VGND VPWR VPWR sky130_fd_sc_hd__decap_8
Xu_mem._0618_ u_mem.mem\[7\]\[7\] u_mem._0153_ u_mem._0205_ VGND VGND VPWR VPWR u_mem._0213_
+ sky130_fd_sc_hd__mux2_1
Xu_mem._0549_ u_mem._0175_ VGND VGND VPWR VPWR u_mem._0023_ sky130_fd_sc_hd__clkbuf_1
Xu_write._91_ wr_clk u_write._08_ VGND VGND VPWR VPWR u_mem.wr_addr\[3\] sky130_fd_sc_hd__dfxtp_2
Xu_sync_rd2wr._49_ wr_clk u_sync_rd2wr._09_ VGND VGND VPWR VPWR u_sync_rd2wr.gray_sync1\[4\]
+ sky130_fd_sc_hd__dfxtp_1
XFILLER_0_8_253 VPWR VGND VPWR VGND sky130_ef_sc_hd__decap_12
XFILLER_0_24_29 VGND VGND VPWR VPWR sky130_fd_sc_hd__fill_1
XFILLER_0_45_137 VGND VGND VPWR VPWR sky130_fd_sc_hd__decap_3
XFILLER_0_30_50 VGND VGND VPWR VPWR sky130_fd_sc_hd__decap_6
XFILLER_0_30_83 VGND VGND VPWR VPWR sky130_fd_sc_hd__fill_1
XTAP_295 VGND VPWR sky130_fd_sc_hd__tapvpwrvgnd_1
XTAP_284 VGND VPWR sky130_fd_sc_hd__tapvpwrvgnd_1
XTAP_273 VGND VPWR sky130_fd_sc_hd__tapvpwrvgnd_1
XTAP_262 VGND VPWR sky130_fd_sc_hd__tapvpwrvgnd_1
XTAP_240 VGND VPWR sky130_fd_sc_hd__tapvpwrvgnd_1
XTAP_251 VGND VPWR sky130_fd_sc_hd__tapvpwrvgnd_1
XFILLER_0_44_170 VGND VGND VPWR VPWR sky130_fd_sc_hd__fill_2
Xu_write._74_ u_write._12_ u_write._30_ u_write._36_ net10 VGND VGND VPWR VPWR u_write._04_
+ sky130_fd_sc_hd__a211oi_1
XFILLER_0_3_3 VPWR VGND VPWR VGND sky130_ef_sc_hd__decap_12
XFILLER_0_35_181 VPWR VGND VPWR VGND sky130_ef_sc_hd__decap_12
Xu_mem._0952_ u_mem._0475_ VGND VGND VPWR VPWR u_mem._0126_ sky130_fd_sc_hd__clkbuf_1
Xu_mem._0883_ u_mem._0151_ u_mem.mem\[14\]\[6\] u_mem._0432_ VGND VGND VPWR VPWR u_mem._0439_
+ sky130_fd_sc_hd__mux2_1
XFILLER_0_41_93 VPWR VGND VPWR VGND sky130_ef_sc_hd__decap_12
XFILLER_0_24_107 VGND VGND VPWR VPWR sky130_fd_sc_hd__fill_1
Xu_write._57_ u_mem.wr_addr\[1\] u_sync_rd2wr.gray_sync2\[0\] VGND VGND VPWR VPWR
+ u_write._25_ sky130_fd_sc_hd__nand2_1
XFILLER_0_17_181 VPWR VGND VPWR VGND sky130_ef_sc_hd__decap_12
XFILLER_0_11_52 VGND VGND VPWR VPWR sky130_fd_sc_hd__fill_1
Xu_mem._1082_ wr_clk u_mem._0110_ VGND VGND VPWR VPWR u_mem.mem\[10\]\[6\] sky130_fd_sc_hd__dfxtp_1
Xu_mem._0866_ u_mem.mem\[1\]\[6\] net7 u_mem._0423_ VGND VGND VPWR VPWR u_mem._0430_
+ sky130_fd_sc_hd__mux2_1
Xu_mem._0935_ u_mem._0466_ VGND VGND VPWR VPWR u_mem._0118_ sky130_fd_sc_hd__clkbuf_1
Xinput1 din[0] VGND VGND VPWR VPWR net1 sky130_fd_sc_hd__clkbuf_2
Xu_mem._0797_ u_mem._0236_ u_mem._0369_ VGND VGND VPWR VPWR u_mem._0370_ sky130_fd_sc_hd__nand2_1
XFILLER_0_32_29 VGND VGND VPWR VPWR sky130_fd_sc_hd__fill_1
XFILLER_0_37_254 VPWR VGND VPWR VGND sky130_ef_sc_hd__decap_12
Xu_mem._0720_ u_mem.mem\[14\]\[2\] u_mem.mem\[15\]\[2\] u_mem._0237_ VGND VGND VPWR
+ VPWR u_mem._0296_ sky130_fd_sc_hd__mux2_1
Xu_mem._0651_ u_mem._0230_ VGND VGND VPWR VPWR u_mem._0070_ sky130_fd_sc_hd__clkbuf_1
Xu_mem._0582_ u_mem._0193_ VGND VGND VPWR VPWR u_mem._0038_ sky130_fd_sc_hd__clkbuf_1
XFILLER_0_28_265 VGND VGND VPWR VPWR sky130_fd_sc_hd__decap_4
Xu_mem._1065_ wr_clk u_mem._0093_ VGND VGND VPWR VPWR u_mem.mem\[14\]\[5\] sky130_fd_sc_hd__dfxtp_1
XFILLER_0_44_3 VPWR VGND VPWR VGND sky130_ef_sc_hd__decap_12
Xu_mem._0918_ u_mem._0457_ VGND VGND VPWR VPWR u_mem._0110_ sky130_fd_sc_hd__clkbuf_1
Xu_mem._0849_ u_mem._0412_ u_mem._0415_ u_mem._0417_ u_mem._0419_ u_mem.rd_addr\[3\]
+ VGND VGND VPWR VPWR u_mem._0420_ sky130_fd_sc_hd__a221o_1
XFILLER_0_19_254 VPWR VGND VPWR VGND sky130_ef_sc_hd__decap_12
Xu_sync_wr2rd._37_ u_sync_wr2rd._18_ VGND VGND VPWR VPWR u_sync_wr2rd._08_ sky130_fd_sc_hd__clkbuf_1
XPHY_7 VGND VGND VPWR VPWR sky130_fd_sc_hd__decap_3
XFILLER_0_40_227 VGND VGND VPWR VPWR sky130_fd_sc_hd__decap_3
XFILLER_0_25_213 VGND VGND VPWR VPWR sky130_fd_sc_hd__fill_2
Xu_mem._0703_ u_mem.mem\[8\]\[1\] u_mem.mem\[9\]\[1\] u_mem._0248_ VGND VGND VPWR
+ VPWR u_mem._0280_ sky130_fd_sc_hd__mux2_1
Xu_mem._0496_ u_mem.mem\[3\]\[2\] u_mem._0143_ u_mem._0139_ VGND VGND VPWR VPWR u_mem._0144_
+ sky130_fd_sc_hd__mux2_1
Xu_mem._0565_ u_mem._0184_ VGND VGND VPWR VPWR u_mem._0030_ sky130_fd_sc_hd__clkbuf_1
Xu_mem._0634_ u_mem._0221_ VGND VGND VPWR VPWR u_mem._0062_ sky130_fd_sc_hd__clkbuf_1
Xu_mem._1048_ rd_clk u_mem._0076_ VGND VGND VPWR VPWR u_mem.dout\[4\] sky130_fd_sc_hd__dfxtp_1
XFILLER_0_0_165 VGND VGND VPWR VPWR sky130_fd_sc_hd__decap_3
XFILLER_0_44_82 VGND VGND VPWR VPWR sky130_fd_sc_hd__fill_2
Xu_mem._0548_ u_mem._0153_ u_mem.mem\[12\]\[7\] u_mem._0167_ VGND VGND VPWR VPWR u_mem._0175_
+ sky130_fd_sc_hd__mux2_1
Xu_mem._0617_ u_mem._0212_ VGND VGND VPWR VPWR u_mem._0054_ sky130_fd_sc_hd__clkbuf_1
Xu_sync_rd2wr._48_ wr_clk u_sync_rd2wr._08_ VGND VGND VPWR VPWR u_sync_rd2wr.gray_sync1\[3\]
+ sky130_fd_sc_hd__dfxtp_1
Xu_write._90_ wr_clk u_write._07_ VGND VGND VPWR VPWR u_mem.wr_addr\[2\] sky130_fd_sc_hd__dfxtp_2
XFILLER_0_8_265 VGND VGND VPWR VPWR sky130_fd_sc_hd__decap_4
XFILLER_0_39_124 VGND VGND VPWR VPWR sky130_fd_sc_hd__decap_8
XFILLER_0_40_29 VGND VGND VPWR VPWR sky130_fd_sc_hd__decap_3
XFILLER_0_4_29 VPWR VGND VPWR VGND sky130_ef_sc_hd__decap_12
XFILLER_0_5_246 VPWR VGND VPWR VGND sky130_ef_sc_hd__decap_12
XFILLER_0_14_85 VGND VGND VPWR VPWR sky130_fd_sc_hd__fill_1
XTAP_230 VGND VPWR sky130_fd_sc_hd__tapvpwrvgnd_1
XTAP_241 VGND VPWR sky130_fd_sc_hd__tapvpwrvgnd_1
XTAP_296 VGND VPWR sky130_fd_sc_hd__tapvpwrvgnd_1
XTAP_285 VGND VPWR sky130_fd_sc_hd__tapvpwrvgnd_1
XTAP_274 VGND VPWR sky130_fd_sc_hd__tapvpwrvgnd_1
XTAP_263 VGND VPWR sky130_fd_sc_hd__tapvpwrvgnd_1
XTAP_252 VGND VPWR sky130_fd_sc_hd__tapvpwrvgnd_1
XFILLER_0_29_190 VGND VGND VPWR VPWR sky130_fd_sc_hd__fill_2
Xu_write._73_ u_write.wr_ptr_bin\[4\] u_write._29_ VGND VGND VPWR VPWR u_write._36_
+ sky130_fd_sc_hd__nor2_1
XFILLER_0_35_193 VPWR VGND VPWR VGND sky130_ef_sc_hd__decap_12
Xu_mem._0882_ u_mem._0438_ VGND VGND VPWR VPWR u_mem._0093_ sky130_fd_sc_hd__clkbuf_1
Xu_mem._0951_ u_mem.mem\[5\]\[6\] net7 u_mem._0468_ VGND VGND VPWR VPWR u_mem._0475_
+ sky130_fd_sc_hd__mux2_1
XFILLER_0_41_152 VGND VGND VPWR VPWR sky130_fd_sc_hd__fill_1
XFILLER_0_33_119 VGND VGND VPWR VPWR sky130_fd_sc_hd__fill_1
XFILLER_0_5_83 VGND VGND VPWR VPWR sky130_fd_sc_hd__decap_3
Xu_write._56_ u_write._21_ u_write._22_ u_write._19_ VGND VGND VPWR VPWR u_write._24_
+ sky130_fd_sc_hd__a21oi_1
XFILLER_0_17_193 VPWR VGND VPWR VGND sky130_ef_sc_hd__decap_12
Xu_mem._1081_ wr_clk u_mem._0109_ VGND VGND VPWR VPWR u_mem.mem\[10\]\[5\] sky130_fd_sc_hd__dfxtp_1
Xu_mem._0934_ u_mem.mem\[0\]\[6\] net7 u_mem._0459_ VGND VGND VPWR VPWR u_mem._0466_
+ sky130_fd_sc_hd__mux2_1
Xu_mem._0865_ u_mem._0429_ VGND VGND VPWR VPWR u_mem._0085_ sky130_fd_sc_hd__clkbuf_1
XFILLER_0_36_50 VPWR VGND VPWR VGND sky130_ef_sc_hd__decap_12
Xinput2 din[1] VGND VGND VPWR VPWR net2 sky130_fd_sc_hd__clkbuf_2
Xu_mem._0796_ u_mem.mem\[6\]\[5\] u_mem.mem\[7\]\[5\] u_mem._0237_ VGND VGND VPWR
+ VPWR u_mem._0369_ sky130_fd_sc_hd__mux2_1
XFILLER_0_37_266 VGND VGND VPWR VPWR sky130_fd_sc_hd__decap_4
Xu_mem._0650_ u_mem.mem\[11\]\[6\] net7 u_mem._0223_ VGND VGND VPWR VPWR u_mem._0230_
+ sky130_fd_sc_hd__mux2_1
Xu_mem._0581_ u_mem._0151_ u_mem.mem\[13\]\[6\] u_mem._0186_ VGND VGND VPWR VPWR u_mem._0193_
+ sky130_fd_sc_hd__mux2_1
Xu_mem._1064_ wr_clk u_mem._0092_ VGND VGND VPWR VPWR u_mem.mem\[14\]\[4\] sky130_fd_sc_hd__dfxtp_1
XFILLER_0_43_269 VGND VGND VPWR VPWR sky130_fd_sc_hd__fill_1
XFILLER_0_11_111 VGND VGND VPWR VPWR sky130_fd_sc_hd__fill_1
XFILLER_0_37_3 VPWR VGND VPWR VGND sky130_ef_sc_hd__decap_12
Xu_mem._0779_ u_mem.mem\[0\]\[4\] u_mem.mem\[1\]\[4\] u_mem._0266_ VGND VGND VPWR
+ VPWR u_mem._0353_ sky130_fd_sc_hd__mux2_1
Xu_mem._0848_ u_mem._0251_ u_mem._0418_ u_mem._0254_ VGND VGND VPWR VPWR u_mem._0419_
+ sky130_fd_sc_hd__a21oi_1
Xu_mem._0917_ u_mem.mem\[10\]\[6\] net7 u_mem._0450_ VGND VGND VPWR VPWR u_mem._0457_
+ sky130_fd_sc_hd__mux2_1
XFILLER_0_2_73 VGND VGND VPWR VPWR sky130_fd_sc_hd__fill_1
XFILLER_0_6_193 VGND VGND VPWR VPWR sky130_fd_sc_hd__decap_3
XFILLER_0_19_266 VGND VGND VPWR VPWR sky130_fd_sc_hd__decap_4
Xu_sync_wr2rd._36_ net10 u_sync_wr2rd.gray_in\[3\] VGND VGND VPWR VPWR u_sync_wr2rd._18_
+ sky130_fd_sc_hd__and2b_1
XPHY_8 VGND VGND VPWR VPWR sky130_fd_sc_hd__decap_3
Xu_mem._0702_ u_mem._0240_ u_mem._0277_ u_mem._0278_ u_mem._0245_ VGND VGND VPWR VPWR
+ u_mem._0279_ sky130_fd_sc_hd__o31a_1
Xu_mem._0633_ u_mem.mem\[6\]\[6\] u_mem._0151_ u_mem._0214_ VGND VGND VPWR VPWR u_mem._0221_
+ sky130_fd_sc_hd__mux2_1
Xu_mem._0495_ net3 VGND VGND VPWR VPWR u_mem._0143_ sky130_fd_sc_hd__buf_2
Xu_mem._0564_ u_mem.mem\[8\]\[6\] u_mem._0151_ u_mem._0177_ VGND VGND VPWR VPWR u_mem._0184_
+ sky130_fd_sc_hd__mux2_1
Xu_mem._1047_ rd_clk u_mem._0075_ VGND VGND VPWR VPWR u_mem.dout\[3\] sky130_fd_sc_hd__dfxtp_1
XFILLER_0_3_130 VGND VGND VPWR VPWR sky130_fd_sc_hd__decap_3
XFILLER_0_38_29 VGND VGND VPWR VPWR sky130_fd_sc_hd__decap_8
XFILLER_0_0_133 VGND VGND VPWR VPWR sky130_fd_sc_hd__decap_3
XFILLER_0_0_177 VGND VGND VPWR VPWR sky130_fd_sc_hd__decap_3
Xu_mem._0616_ u_mem.mem\[7\]\[6\] u_mem._0151_ u_mem._0205_ VGND VGND VPWR VPWR u_mem._0212_
+ sky130_fd_sc_hd__mux2_1
Xu_mem._0547_ u_mem._0174_ VGND VGND VPWR VPWR u_mem._0022_ sky130_fd_sc_hd__clkbuf_1
Xu_sync_rd2wr._47_ wr_clk u_sync_rd2wr._07_ VGND VGND VPWR VPWR u_sync_rd2wr.gray_sync1\[2\]
+ sky130_fd_sc_hd__dfxtp_1
XFILLER_0_12_250 VGND VGND VPWR VPWR sky130_fd_sc_hd__fill_2
XFILLER_0_45_117 VPWR VGND VPWR VGND sky130_ef_sc_hd__decap_12
XFILLER_0_14_53 VGND VGND VPWR VPWR sky130_fd_sc_hd__decap_3
XFILLER_0_5_258 VPWR VGND VPWR VGND sky130_ef_sc_hd__decap_12
XFILLER_0_5_225 VPWR VGND VPWR VGND sky130_ef_sc_hd__decap_12
XFILLER_0_30_74 VGND VGND VPWR VPWR sky130_fd_sc_hd__fill_1
XFILLER_0_30_85 VPWR VGND VPWR VGND sky130_ef_sc_hd__decap_12
XTAP_275 VGND VPWR sky130_fd_sc_hd__tapvpwrvgnd_1
XTAP_264 VGND VPWR sky130_fd_sc_hd__tapvpwrvgnd_1
XTAP_253 VGND VPWR sky130_fd_sc_hd__tapvpwrvgnd_1
XTAP_220 VGND VPWR sky130_fd_sc_hd__tapvpwrvgnd_1
XTAP_231 VGND VPWR sky130_fd_sc_hd__tapvpwrvgnd_1
XTAP_242 VGND VPWR sky130_fd_sc_hd__tapvpwrvgnd_1
XTAP_297 VGND VPWR sky130_fd_sc_hd__tapvpwrvgnd_1
XTAP_286 VGND VPWR sky130_fd_sc_hd__tapvpwrvgnd_1
Xu_write._72_ u_write._35_ VGND VGND VPWR VPWR u_write._03_ sky130_fd_sc_hd__clkbuf_1
Xu_mem._0950_ u_mem._0474_ VGND VGND VPWR VPWR u_mem._0125_ sky130_fd_sc_hd__clkbuf_1
Xu_mem._0881_ u_mem._0149_ u_mem.mem\[14\]\[5\] u_mem._0432_ VGND VGND VPWR VPWR u_mem._0438_
+ sky130_fd_sc_hd__mux2_1
XFILLER_0_18_106 VPWR VGND VPWR VGND sky130_ef_sc_hd__decap_12
XFILLER_0_41_120 VPWR VGND VPWR VGND sky130_ef_sc_hd__decap_12
XFILLER_0_1_261 VGND VGND VPWR VPWR sky130_fd_sc_hd__decap_6
XFILLER_0_5_95 VPWR VGND VPWR VGND sky130_ef_sc_hd__decap_12
XFILLER_0_5_51 VGND VGND VPWR VPWR sky130_fd_sc_hd__decap_4
Xu_write._55_ u_write._19_ u_write._21_ u_write._22_ VGND VGND VPWR VPWR u_write._23_
+ sky130_fd_sc_hd__and3_1
Xu_mem._1080_ wr_clk u_mem._0108_ VGND VGND VPWR VPWR u_mem.mem\[10\]\[4\] sky130_fd_sc_hd__dfxtp_1
XFILLER_0_23_131 VGND VGND VPWR VPWR sky130_fd_sc_hd__decap_3
Xu_mem._0933_ u_mem._0465_ VGND VGND VPWR VPWR u_mem._0117_ sky130_fd_sc_hd__clkbuf_1
XFILLER_0_39_7 VPWR VGND VPWR VGND sky130_ef_sc_hd__decap_12
Xu_mem._0795_ u_mem._0360_ u_mem._0363_ u_mem._0365_ u_mem._0367_ u_mem._0256_ VGND
+ VGND VPWR VPWR u_mem._0368_ sky130_fd_sc_hd__a221o_1
Xu_mem._0864_ u_mem.mem\[1\]\[5\] net6 u_mem._0423_ VGND VGND VPWR VPWR u_mem._0429_
+ sky130_fd_sc_hd__mux2_1
XFILLER_0_36_73 VGND VGND VPWR VPWR sky130_fd_sc_hd__decap_8
XFILLER_0_36_62 VGND VGND VPWR VPWR sky130_fd_sc_hd__fill_2
XTAP_92 VGND VPWR sky130_fd_sc_hd__tapvpwrvgnd_1
Xinput3 din[2] VGND VGND VPWR VPWR net3 sky130_fd_sc_hd__clkbuf_2
XFILLER_0_37_234 VGND VGND VPWR VPWR sky130_fd_sc_hd__fill_1
Xu_read._89_ rd_clk u_read._02_ VGND VGND VPWR VPWR u_read.rd_ptr_gray\[2\] sky130_fd_sc_hd__dfxtp_1
X_7_ u_mem.dout\[7\] VGND VGND VPWR VPWR net19 sky130_fd_sc_hd__clkbuf_1
Xu_mem._0580_ u_mem._0192_ VGND VGND VPWR VPWR u_mem._0037_ sky130_fd_sc_hd__clkbuf_1
Xu_mem._1063_ wr_clk u_mem._0091_ VGND VGND VPWR VPWR u_mem.mem\[14\]\[3\] sky130_fd_sc_hd__dfxtp_1
XFILLER_0_11_167 VGND VGND VPWR VPWR sky130_fd_sc_hd__fill_1
Xu_mem._0916_ u_mem._0456_ VGND VGND VPWR VPWR u_mem._0109_ sky130_fd_sc_hd__clkbuf_1
Xu_mem._0847_ u_mem.mem\[2\]\[7\] u_mem.mem\[3\]\[7\] u_mem._0270_ VGND VGND VPWR
+ VPWR u_mem._0418_ sky130_fd_sc_hd__mux2_1
XFILLER_0_2_41 VPWR VGND VPWR VGND sky130_ef_sc_hd__decap_12
Xu_mem._0778_ u_mem._0240_ u_mem._0350_ u_mem._0351_ u_mem._0245_ VGND VGND VPWR VPWR
+ u_mem._0352_ sky130_fd_sc_hd__o31a_1
Xu_sync_wr2rd._35_ u_sync_wr2rd._17_ VGND VGND VPWR VPWR u_sync_wr2rd._07_ sky130_fd_sc_hd__clkbuf_1
XFILLER_0_6_161 VPWR VGND VPWR VGND sky130_ef_sc_hd__decap_12
XPHY_9 VGND VGND VPWR VPWR sky130_fd_sc_hd__decap_3
Xu_mem._0701_ u_mem.mem\[13\]\[1\] u_mem._0243_ VGND VGND VPWR VPWR u_mem._0278_ sky130_fd_sc_hd__and2b_1
Xu_mem._0632_ u_mem._0220_ VGND VGND VPWR VPWR u_mem._0061_ sky130_fd_sc_hd__clkbuf_1
Xu_mem._0563_ u_mem._0183_ VGND VGND VPWR VPWR u_mem._0029_ sky130_fd_sc_hd__clkbuf_1
Xu_mem._0494_ u_mem._0142_ VGND VGND VPWR VPWR u_mem._0001_ sky130_fd_sc_hd__clkbuf_1
Xu_mem._1046_ rd_clk u_mem._0074_ VGND VGND VPWR VPWR u_mem.dout\[2\] sky130_fd_sc_hd__dfxtp_1
XFILLER_0_3_175 VGND VGND VPWR VPWR sky130_fd_sc_hd__fill_1
XFILLER_0_30_262 VGND VGND VPWR VPWR sky130_fd_sc_hd__decap_8
XFILLER_0_0_189 VGND VGND VPWR VPWR sky130_fd_sc_hd__decap_6
XFILLER_0_44_62 VPWR VGND VPWR VGND sky130_ef_sc_hd__decap_12
Xu_mem._0615_ u_mem._0211_ VGND VGND VPWR VPWR u_mem._0053_ sky130_fd_sc_hd__clkbuf_1
Xu_mem._0546_ u_mem._0151_ u_mem.mem\[12\]\[6\] u_mem._0167_ VGND VGND VPWR VPWR u_mem._0174_
+ sky130_fd_sc_hd__mux2_1
Xu_sync_rd2wr._46_ wr_clk u_sync_rd2wr._06_ VGND VGND VPWR VPWR u_sync_rd2wr.gray_sync1\[1\]
+ sky130_fd_sc_hd__dfxtp_1
Xu_mem._1029_ wr_clk u_mem._0057_ VGND VGND VPWR VPWR u_mem.mem\[6\]\[1\] sky130_fd_sc_hd__dfxtp_1
XFILLER_0_45_129 VGND VGND VPWR VPWR sky130_fd_sc_hd__decap_8
XFILLER_0_14_65 VPWR VGND VPWR VGND sky130_ef_sc_hd__decap_12
XFILLER_0_5_237 VGND VGND VPWR VPWR sky130_fd_sc_hd__decap_6
XFILLER_0_30_97 VGND VGND VPWR VPWR sky130_fd_sc_hd__decap_4
XTAP_298 VGND VPWR sky130_fd_sc_hd__tapvpwrvgnd_1
XTAP_287 VGND VPWR sky130_fd_sc_hd__tapvpwrvgnd_1
XTAP_276 VGND VPWR sky130_fd_sc_hd__tapvpwrvgnd_1
XTAP_265 VGND VPWR sky130_fd_sc_hd__tapvpwrvgnd_1
XTAP_254 VGND VPWR sky130_fd_sc_hd__tapvpwrvgnd_1
XTAP_210 VGND VPWR sky130_fd_sc_hd__tapvpwrvgnd_1
XTAP_221 VGND VPWR sky130_fd_sc_hd__tapvpwrvgnd_1
XTAP_232 VGND VPWR sky130_fd_sc_hd__tapvpwrvgnd_1
XTAP_243 VGND VPWR sky130_fd_sc_hd__tapvpwrvgnd_1
XFILLER_0_12_3 VGND VGND VPWR VPWR sky130_fd_sc_hd__decap_4
Xu_mem._0529_ u_mem._0164_ VGND VGND VPWR VPWR u_mem._0014_ sky130_fd_sc_hd__clkbuf_1
Xu_write._71_ net10 u_write._34_ VGND VGND VPWR VPWR u_write._35_ sky130_fd_sc_hd__and2b_1
Xu_sync_rd2wr._29_ u_sync_rd2wr._14_ VGND VGND VPWR VPWR u_sync_rd2wr._04_ sky130_fd_sc_hd__clkbuf_1
Xu_mem._0880_ u_mem._0437_ VGND VGND VPWR VPWR u_mem._0092_ sky130_fd_sc_hd__clkbuf_1
XFILLER_0_18_118 VGND VGND VPWR VPWR sky130_fd_sc_hd__fill_1
XFILLER_0_41_132 VGND VGND VPWR VPWR sky130_fd_sc_hd__decap_4
XFILLER_0_26_195 VGND VGND VPWR VPWR sky130_fd_sc_hd__fill_1
XFILLER_0_5_63 VGND VGND VPWR VPWR sky130_fd_sc_hd__fill_1
Xu_write._54_ u_write._09_ u_write._15_ u_write._20_ VGND VGND VPWR VPWR u_write._22_
+ sky130_fd_sc_hd__o21bai_2
XFILLER_0_32_110 VGND VGND VPWR VPWR sky130_fd_sc_hd__fill_2
XFILLER_0_1_3 VPWR VGND VPWR VGND sky130_ef_sc_hd__decap_12
Xu_mem._0932_ u_mem.mem\[0\]\[5\] net6 u_mem._0459_ VGND VGND VPWR VPWR u_mem._0465_
+ sky130_fd_sc_hd__mux2_1
Xinput4 din[3] VGND VGND VPWR VPWR net4 sky130_fd_sc_hd__clkbuf_2
Xu_mem._0863_ u_mem._0428_ VGND VGND VPWR VPWR u_mem._0084_ sky130_fd_sc_hd__clkbuf_1
Xu_mem._0794_ u_mem._0251_ u_mem._0366_ u_mem._0263_ VGND VGND VPWR VPWR u_mem._0367_
+ sky130_fd_sc_hd__a21oi_1
XFILLER_0_36_96 VPWR VGND VPWR VGND sky130_ef_sc_hd__decap_12
XTAP_93 VGND VPWR sky130_fd_sc_hd__tapvpwrvgnd_1
Xu_read._88_ rd_clk u_read._01_ VGND VGND VPWR VPWR u_read.rd_ptr_gray\[1\] sky130_fd_sc_hd__dfxtp_1
X_6_ u_mem.dout\[6\] VGND VGND VPWR VPWR net18 sky130_fd_sc_hd__clkbuf_1
XFILLER_0_43_249 VPWR VGND VPWR VGND sky130_ef_sc_hd__decap_12
Xu_mem._1062_ wr_clk u_mem._0090_ VGND VGND VPWR VPWR u_mem.mem\[14\]\[2\] sky130_fd_sc_hd__dfxtp_1
XFILLER_0_11_113 VPWR VGND VPWR VGND sky130_ef_sc_hd__decap_12
Xu_mem._0915_ u_mem.mem\[10\]\[5\] net6 u_mem._0450_ VGND VGND VPWR VPWR u_mem._0456_
+ sky130_fd_sc_hd__mux2_1
Xu_mem._0846_ u_mem._0265_ u_mem._0416_ VGND VGND VPWR VPWR u_mem._0417_ sky130_fd_sc_hd__or2b_1
XFILLER_0_2_53 VPWR VGND VPWR VGND sky130_ef_sc_hd__decap_12
Xu_mem._0777_ u_mem.mem\[5\]\[4\] u_mem._0243_ VGND VGND VPWR VPWR u_mem._0351_ sky130_fd_sc_hd__and2b_1
Xu_sync_wr2rd._34_ net10 u_sync_wr2rd.gray_in\[2\] VGND VGND VPWR VPWR u_sync_wr2rd._17_
+ sky130_fd_sc_hd__and2b_1
XFILLER_0_6_173 VGND VGND VPWR VPWR sky130_fd_sc_hd__decap_4
XFILLER_0_25_205 VGND VGND VPWR VPWR sky130_fd_sc_hd__decap_8
Xu_mem._0700_ u_mem._0241_ u_mem.mem\[12\]\[1\] VGND VGND VPWR VPWR u_mem._0277_ sky130_fd_sc_hd__nor2_1
Xu_mem._0493_ u_mem.mem\[3\]\[1\] u_mem._0141_ u_mem._0139_ VGND VGND VPWR VPWR u_mem._0142_
+ sky130_fd_sc_hd__mux2_1
XFILLER_0_17_32 VGND VGND VPWR VPWR sky130_fd_sc_hd__decap_4
Xu_mem._0631_ u_mem.mem\[6\]\[5\] u_mem._0149_ u_mem._0214_ VGND VGND VPWR VPWR u_mem._0220_
+ sky130_fd_sc_hd__mux2_1
Xu_mem._0562_ u_mem.mem\[8\]\[5\] u_mem._0149_ u_mem._0177_ VGND VGND VPWR VPWR u_mem._0183_
+ sky130_fd_sc_hd__mux2_1
XFILLER_0_16_205 VGND VGND VPWR VPWR sky130_fd_sc_hd__decap_4
Xu_mem._1045_ rd_clk u_mem._0073_ VGND VGND VPWR VPWR u_mem.dout\[1\] sky130_fd_sc_hd__dfxtp_1
XFILLER_0_42_3 VPWR VGND VPWR VGND sky130_ef_sc_hd__decap_12
Xu_mem._0829_ u_mem._0234_ u_mem._0389_ u_mem._0399_ u_mem._0400_ VGND VGND VPWR VPWR
+ u_mem._0078_ sky130_fd_sc_hd__a31oi_1
XFILLER_0_0_113 VPWR VGND VPWR VGND sky130_ef_sc_hd__decap_12
XFILLER_0_44_74 VGND VGND VPWR VPWR sky130_fd_sc_hd__fill_2
XFILLER_0_44_41 VPWR VGND VPWR VGND sky130_ef_sc_hd__decap_12
Xu_mem._0614_ u_mem.mem\[7\]\[5\] u_mem._0149_ u_mem._0205_ VGND VGND VPWR VPWR u_mem._0211_
+ sky130_fd_sc_hd__mux2_1
Xu_mem._0545_ u_mem._0173_ VGND VGND VPWR VPWR u_mem._0021_ sky130_fd_sc_hd__clkbuf_1
Xu_sync_rd2wr._45_ wr_clk u_sync_rd2wr._05_ VGND VGND VPWR VPWR u_sync_rd2wr.gray_sync1\[0\]
+ sky130_fd_sc_hd__dfxtp_1
XFILLER_0_8_246 VGND VGND VPWR VPWR sky130_fd_sc_hd__decap_6
Xu_mem._1028_ wr_clk u_mem._0056_ VGND VGND VPWR VPWR u_mem.mem\[6\]\[0\] sky130_fd_sc_hd__dfxtp_1
XFILLER_0_14_11 VGND VGND VPWR VPWR sky130_fd_sc_hd__fill_1
XTAP_299 VGND VPWR sky130_fd_sc_hd__tapvpwrvgnd_1
XTAP_288 VGND VPWR sky130_fd_sc_hd__tapvpwrvgnd_1
XTAP_277 VGND VPWR sky130_fd_sc_hd__tapvpwrvgnd_1
XTAP_266 VGND VPWR sky130_fd_sc_hd__tapvpwrvgnd_1
XTAP_255 VGND VPWR sky130_fd_sc_hd__tapvpwrvgnd_1
XTAP_200 VGND VPWR sky130_fd_sc_hd__tapvpwrvgnd_1
XTAP_211 VGND VPWR sky130_fd_sc_hd__tapvpwrvgnd_1
XTAP_222 VGND VPWR sky130_fd_sc_hd__tapvpwrvgnd_1
XTAP_233 VGND VPWR sky130_fd_sc_hd__tapvpwrvgnd_1
XTAP_244 VGND VPWR sky130_fd_sc_hd__tapvpwrvgnd_1
XFILLER_0_36_108 VPWR VGND VPWR VGND sky130_ef_sc_hd__decap_12
Xu_mem._0528_ u_mem.mem\[4\]\[6\] u_mem._0151_ u_mem._0157_ VGND VGND VPWR VPWR u_mem._0164_
+ sky130_fd_sc_hd__mux2_1
XFILLER_0_44_163 VGND VGND VPWR VPWR sky130_fd_sc_hd__fill_1
Xu_write._70_ u_sync_wr2rd.gray_in\[3\] u_write._13_ u_write._29_ VGND VGND VPWR VPWR
+ u_write._34_ sky130_fd_sc_hd__mux2_1
Xu_sync_rd2wr._28_ net10 u_sync_rd2wr.gray_sync1\[4\] VGND VGND VPWR VPWR u_sync_rd2wr._14_
+ sky130_fd_sc_hd__and2b_1
XFILLER_0_25_54 VGND VGND VPWR VPWR sky130_fd_sc_hd__fill_2
XFILLER_0_41_111 VGND VGND VPWR VPWR sky130_fd_sc_hd__fill_1
Xu_write._53_ u_write._09_ u_write._15_ u_write._20_ VGND VGND VPWR VPWR u_write._21_
+ sky130_fd_sc_hd__or3b_1
Xu_mem._0862_ u_mem.mem\[1\]\[4\] net5 u_mem._0423_ VGND VGND VPWR VPWR u_mem._0428_
+ sky130_fd_sc_hd__mux2_1
Xu_mem._0931_ u_mem._0464_ VGND VGND VPWR VPWR u_mem._0116_ sky130_fd_sc_hd__clkbuf_1
Xinput5 din[4] VGND VGND VPWR VPWR net5 sky130_fd_sc_hd__clkbuf_2
Xu_mem._0793_ u_mem.mem\[10\]\[5\] u_mem.mem\[11\]\[5\] u_mem._0252_ VGND VGND VPWR
+ VPWR u_mem._0366_ sky130_fd_sc_hd__mux2_1
XTAP_94 VGND VPWR sky130_fd_sc_hd__tapvpwrvgnd_1
XFILLER_0_14_177 VGND VGND VPWR VPWR sky130_fd_sc_hd__fill_1
Xu_read._87_ rd_clk u_read._00_ VGND VGND VPWR VPWR u_read.rd_ptr_gray\[0\] sky130_fd_sc_hd__dfxtp_1
XFILLER_0_20_114 VGND VGND VPWR VPWR sky130_fd_sc_hd__fill_1
X_5_ u_mem.dout\[5\] VGND VGND VPWR VPWR net17 sky130_fd_sc_hd__clkbuf_1
XFILLER_0_7_119 VPWR VGND VPWR VGND sky130_ef_sc_hd__decap_12
Xu_mem._1061_ wr_clk u_mem._0089_ VGND VGND VPWR VPWR u_mem.mem\[14\]\[1\] sky130_fd_sc_hd__dfxtp_1
XFILLER_0_22_88 VPWR VGND VPWR VGND sky130_ef_sc_hd__decap_12
XFILLER_0_28_269 VGND VGND VPWR VPWR sky130_fd_sc_hd__fill_1
Xu_mem._0845_ u_mem.mem\[0\]\[7\] u_mem.mem\[1\]\[7\] u_mem._0248_ VGND VGND VPWR
+ VPWR u_mem._0416_ sky130_fd_sc_hd__mux2_1
XFILLER_0_11_125 VPWR VGND VPWR VGND sky130_ef_sc_hd__decap_12
XFILLER_0_11_169 VGND VGND VPWR VPWR sky130_fd_sc_hd__decap_6
Xu_mem._0914_ u_mem._0455_ VGND VGND VPWR VPWR u_mem._0108_ sky130_fd_sc_hd__clkbuf_1
XFILLER_0_2_65 VGND VGND VPWR VPWR sky130_fd_sc_hd__decap_8
Xu_mem._0776_ u_mem._0241_ u_mem.mem\[4\]\[4\] VGND VGND VPWR VPWR u_mem._0350_ sky130_fd_sc_hd__nor2_1
XFILLER_0_34_217 VGND VGND VPWR VPWR sky130_fd_sc_hd__fill_1
XFILLER_0_19_225 VGND VGND VPWR VPWR sky130_fd_sc_hd__fill_1
Xu_sync_wr2rd._33_ u_sync_wr2rd._16_ VGND VGND VPWR VPWR u_sync_wr2rd._06_ sky130_fd_sc_hd__clkbuf_1
Xu_mem._0630_ u_mem._0219_ VGND VGND VPWR VPWR u_mem._0060_ sky130_fd_sc_hd__clkbuf_1
Xu_mem._0492_ net2 VGND VGND VPWR VPWR u_mem._0141_ sky130_fd_sc_hd__buf_2
XFILLER_0_17_66 VGND VGND VPWR VPWR sky130_fd_sc_hd__fill_1
Xu_mem._0561_ u_mem._0182_ VGND VGND VPWR VPWR u_mem._0028_ sky130_fd_sc_hd__clkbuf_1
Xu_mem._1044_ rd_clk u_mem._0072_ VGND VGND VPWR VPWR u_mem.dout\[0\] sky130_fd_sc_hd__dfxtp_1
XFILLER_0_3_122 VGND VGND VPWR VPWR sky130_fd_sc_hd__decap_8
XFILLER_0_35_3 VGND VGND VPWR VPWR sky130_fd_sc_hd__fill_2
Xu_mem._0759_ u_mem.mem\[2\]\[3\] u_mem.mem\[3\]\[3\] u_mem._0270_ VGND VGND VPWR
+ VPWR u_mem._0334_ sky130_fd_sc_hd__mux2_1
Xu_mem._0828_ u_mem.dout\[6\] u_mem._0233_ VGND VGND VPWR VPWR u_mem._0400_ sky130_fd_sc_hd__nor2_1
XFILLER_0_0_125 VGND VGND VPWR VPWR sky130_fd_sc_hd__decap_8
XFILLER_0_21_264 VGND VGND VPWR VPWR sky130_fd_sc_hd__decap_3
XFILLER_0_0_169 VGND VGND VPWR VPWR sky130_fd_sc_hd__decap_8
Xu_mem._0613_ u_mem._0210_ VGND VGND VPWR VPWR u_mem._0052_ sky130_fd_sc_hd__clkbuf_1
XFILLER_0_44_53 VGND VGND VPWR VPWR sky130_fd_sc_hd__decap_6
Xu_mem._0544_ u_mem._0149_ u_mem.mem\[12\]\[5\] u_mem._0167_ VGND VGND VPWR VPWR u_mem._0173_
+ sky130_fd_sc_hd__mux2_1
Xu_sync_rd2wr._44_ wr_clk u_sync_rd2wr._04_ VGND VGND VPWR VPWR u_sync_rd2wr.gray_sync2\[4\]
+ sky130_fd_sc_hd__dfxtp_1
XFILLER_0_8_269 VGND VGND VPWR VPWR sky130_fd_sc_hd__fill_1
Xu_mem._1027_ wr_clk u_mem._0055_ VGND VGND VPWR VPWR u_mem.mem\[7\]\[7\] sky130_fd_sc_hd__dfxtp_1
XFILLER_0_12_220 VPWR VGND VPWR VGND sky130_ef_sc_hd__decap_12
XFILLER_0_12_253 VPWR VGND VPWR VGND sky130_ef_sc_hd__decap_12
XFILLER_0_39_117 VGND VGND VPWR VPWR sky130_fd_sc_hd__fill_1
XFILLER_0_45_109 VGND VGND VPWR VPWR sky130_fd_sc_hd__decap_3
XFILLER_0_38_183 VGND VGND VPWR VPWR sky130_fd_sc_hd__fill_1
XFILLER_0_38_161 VGND VGND VPWR VPWR sky130_fd_sc_hd__decap_8
XFILLER_0_14_89 VGND VGND VPWR VPWR sky130_fd_sc_hd__fill_2
XTAP_201 VGND VPWR sky130_fd_sc_hd__tapvpwrvgnd_1
XTAP_212 VGND VPWR sky130_fd_sc_hd__tapvpwrvgnd_1
XTAP_223 VGND VPWR sky130_fd_sc_hd__tapvpwrvgnd_1
XFILLER_0_30_66 VGND VGND VPWR VPWR sky130_fd_sc_hd__decap_8
XTAP_289 VGND VPWR sky130_fd_sc_hd__tapvpwrvgnd_1
XTAP_278 VGND VPWR sky130_fd_sc_hd__tapvpwrvgnd_1
XTAP_267 VGND VPWR sky130_fd_sc_hd__tapvpwrvgnd_1
XTAP_256 VGND VPWR sky130_fd_sc_hd__tapvpwrvgnd_1
XTAP_234 VGND VPWR sky130_fd_sc_hd__tapvpwrvgnd_1
XTAP_245 VGND VPWR sky130_fd_sc_hd__tapvpwrvgnd_1
Xu_mem._0527_ u_mem._0163_ VGND VGND VPWR VPWR u_mem._0013_ sky130_fd_sc_hd__clkbuf_1
XFILLER_0_44_131 VGND VGND VPWR VPWR sky130_fd_sc_hd__decap_8
Xu_sync_rd2wr._27_ u_sync_rd2wr._13_ VGND VGND VPWR VPWR u_sync_rd2wr._03_ sky130_fd_sc_hd__clkbuf_1
XFILLER_0_4_250 VGND VGND VPWR VPWR sky130_fd_sc_hd__fill_2
XFILLER_0_25_88 VGND VGND VPWR VPWR sky130_fd_sc_hd__decap_3
XFILLER_0_26_175 VPWR VGND VPWR VGND sky130_ef_sc_hd__decap_12
XFILLER_0_41_189 VGND VGND VPWR VPWR sky130_fd_sc_hd__decap_3
Xu_write._52_ u_mem.wr_addr\[1\] u_mem.wr_addr\[0\] VGND VGND VPWR VPWR u_write._20_
+ sky130_fd_sc_hd__xnor2_1
Xu_mem._0861_ u_mem._0427_ VGND VGND VPWR VPWR u_mem._0083_ sky130_fd_sc_hd__clkbuf_1
Xu_mem._0930_ u_mem.mem\[0\]\[4\] net5 u_mem._0459_ VGND VGND VPWR VPWR u_mem._0464_
+ sky130_fd_sc_hd__mux2_1
Xu_mem._0792_ u_mem._0247_ u_mem._0364_ VGND VGND VPWR VPWR u_mem._0365_ sky130_fd_sc_hd__or2b_1
Xinput6 din[5] VGND VGND VPWR VPWR net6 sky130_fd_sc_hd__clkbuf_2
XTAP_95 VGND VPWR sky130_fd_sc_hd__tapvpwrvgnd_1
Xu_read._86_ u_mem.rd_addr\[3\] u_read._20_ u_read._42_ u_read._22_ VGND VGND VPWR
+ VPWR u_read._08_ sky130_fd_sc_hd__o211a_1
X_4_ u_mem.dout\[4\] VGND VGND VPWR VPWR net16 sky130_fd_sc_hd__clkbuf_1
XPHY_90 VGND VGND VPWR VPWR sky130_fd_sc_hd__decap_3
Xu_mem._1060_ wr_clk u_mem._0088_ VGND VGND VPWR VPWR u_mem.mem\[14\]\[0\] sky130_fd_sc_hd__dfxtp_1
XFILLER_0_22_23 VGND VGND VPWR VPWR sky130_fd_sc_hd__decap_4
XFILLER_0_28_215 VGND VGND VPWR VPWR sky130_fd_sc_hd__fill_1
XFILLER_0_11_137 VPWR VGND VPWR VGND sky130_ef_sc_hd__decap_12
XFILLER_0_22_78 VGND VGND VPWR VPWR sky130_fd_sc_hd__decap_6
Xu_mem._0775_ u_mem._0236_ u_mem._0348_ VGND VGND VPWR VPWR u_mem._0349_ sky130_fd_sc_hd__nand2_1
Xu_mem._0913_ u_mem.mem\[10\]\[4\] net5 u_mem._0450_ VGND VGND VPWR VPWR u_mem._0455_
+ sky130_fd_sc_hd__mux2_1
Xu_mem._0844_ u_mem._0240_ u_mem._0413_ u_mem._0414_ u_mem._0245_ VGND VGND VPWR VPWR
+ u_mem._0415_ sky130_fd_sc_hd__o31a_1
XFILLER_0_42_251 VGND VGND VPWR VPWR sky130_fd_sc_hd__fill_1
Xu_sync_wr2rd._32_ net10 u_sync_wr2rd.gray_in\[1\] VGND VGND VPWR VPWR u_sync_wr2rd._16_
+ sky130_fd_sc_hd__and2b_1
XFILLER_0_6_197 VGND VGND VPWR VPWR sky130_fd_sc_hd__fill_1
XFILLER_0_10_181 VGND VGND VPWR VPWR sky130_fd_sc_hd__decap_6
XFILLER_0_10_192 VGND VGND VPWR VPWR sky130_fd_sc_hd__decap_4
XFILLER_0_33_262 VGND VGND VPWR VPWR sky130_fd_sc_hd__decap_8
Xu_read._69_ u_mem.rd_addr\[3\] u_read._30_ VGND VGND VPWR VPWR u_read._31_ sky130_fd_sc_hd__nor2_1
Xu_mem._0491_ u_mem._0140_ VGND VGND VPWR VPWR u_mem._0000_ sky130_fd_sc_hd__clkbuf_1
Xu_mem._0560_ u_mem.mem\[8\]\[4\] u_mem._0147_ u_mem._0177_ VGND VGND VPWR VPWR u_mem._0182_
+ sky130_fd_sc_hd__mux2_1
Xu_mem._1043_ wr_clk u_mem._0071_ VGND VGND VPWR VPWR u_mem.mem\[11\]\[7\] sky130_fd_sc_hd__dfxtp_1
XFILLER_0_24_251 VGND VGND VPWR VPWR sky130_fd_sc_hd__fill_1
Xu_mem._0758_ u_mem._0265_ u_mem._0332_ VGND VGND VPWR VPWR u_mem._0333_ sky130_fd_sc_hd__or2b_1
XFILLER_0_28_3 VGND VGND VPWR VPWR sky130_fd_sc_hd__decap_6
Xu_mem._0827_ u_mem._0391_ u_mem._0394_ u_mem._0396_ u_mem._0398_ u_mem.rd_addr\[3\]
+ VGND VGND VPWR VPWR u_mem._0399_ sky130_fd_sc_hd__a221o_1
Xu_mem._0689_ u_mem.mem\[0\]\[0\] u_mem.mem\[1\]\[0\] u_mem._0266_ VGND VGND VPWR
+ VPWR u_mem._0267_ sky130_fd_sc_hd__mux2_1
XFILLER_0_15_262 VGND VGND VPWR VPWR sky130_fd_sc_hd__decap_8
XFILLER_0_21_221 VGND VGND VPWR VPWR sky130_fd_sc_hd__decap_3
Xu_mem._0543_ u_mem._0172_ VGND VGND VPWR VPWR u_mem._0020_ sky130_fd_sc_hd__clkbuf_1
Xu_mem._0612_ u_mem.mem\[7\]\[4\] u_mem._0147_ u_mem._0205_ VGND VGND VPWR VPWR u_mem._0210_
+ sky130_fd_sc_hd__mux2_1
Xu_sync_rd2wr._43_ wr_clk u_sync_rd2wr._03_ VGND VGND VPWR VPWR u_sync_rd2wr.gray_sync2\[3\]
+ sky130_fd_sc_hd__dfxtp_1
Xu_mem._1026_ wr_clk u_mem._0054_ VGND VGND VPWR VPWR u_mem.mem\[7\]\[6\] sky130_fd_sc_hd__dfxtp_1
XFILLER_0_12_232 VPWR VGND VPWR VGND sky130_ef_sc_hd__decap_12
XFILLER_0_12_265 VGND VGND VPWR VPWR sky130_fd_sc_hd__decap_4
XFILLER_0_30_56 VGND VGND VPWR VPWR sky130_fd_sc_hd__fill_1
XFILLER_0_39_54 VGND VGND VPWR VPWR sky130_fd_sc_hd__fill_2
XTAP_257 VGND VPWR sky130_fd_sc_hd__tapvpwrvgnd_1
XTAP_202 VGND VPWR sky130_fd_sc_hd__tapvpwrvgnd_1
XTAP_213 VGND VPWR sky130_fd_sc_hd__tapvpwrvgnd_1
XTAP_224 VGND VPWR sky130_fd_sc_hd__tapvpwrvgnd_1
XTAP_235 VGND VPWR sky130_fd_sc_hd__tapvpwrvgnd_1
XTAP_246 VGND VPWR sky130_fd_sc_hd__tapvpwrvgnd_1
XTAP_279 VGND VPWR sky130_fd_sc_hd__tapvpwrvgnd_1
XTAP_268 VGND VPWR sky130_fd_sc_hd__tapvpwrvgnd_1
Xu_mem._0526_ u_mem.mem\[4\]\[5\] u_mem._0149_ u_mem._0157_ VGND VGND VPWR VPWR u_mem._0163_
+ sky130_fd_sc_hd__mux2_1
Xu_sync_rd2wr._26_ net10 u_sync_rd2wr.gray_sync1\[3\] VGND VGND VPWR VPWR u_sync_rd2wr._13_
+ sky130_fd_sc_hd__and2b_1
XFILLER_0_29_151 VGND VGND VPWR VPWR sky130_fd_sc_hd__decap_8
XFILLER_0_4_262 VGND VGND VPWR VPWR sky130_fd_sc_hd__decap_8
Xu_mem._1009_ wr_clk u_mem._0037_ VGND VGND VPWR VPWR u_mem.mem\[13\]\[5\] sky130_fd_sc_hd__dfxtp_1
XFILLER_0_35_154 VGND VGND VPWR VPWR sky130_fd_sc_hd__decap_3
XFILLER_0_41_55 VGND VGND VPWR VPWR sky130_fd_sc_hd__fill_1
XFILLER_0_1_221 VGND VGND VPWR VPWR sky130_fd_sc_hd__decap_3
XFILLER_0_26_187 VGND VGND VPWR VPWR sky130_fd_sc_hd__decap_8
XFILLER_0_5_55 VGND VGND VPWR VPWR sky130_fd_sc_hd__fill_1
XFILLER_0_10_3 VGND VGND VPWR VPWR sky130_fd_sc_hd__decap_8
Xu_mem._0509_ u_mem._0152_ VGND VGND VPWR VPWR u_mem._0006_ sky130_fd_sc_hd__clkbuf_1
Xu_write._51_ u_sync_rd2wr.gray_sync2\[1\] VGND VGND VPWR VPWR u_write._19_ sky130_fd_sc_hd__inv_2
XFILLER_0_11_36 VPWR VGND VPWR VGND sky130_ef_sc_hd__decap_12
XFILLER_0_23_113 VGND VGND VPWR VPWR sky130_fd_sc_hd__decap_6
XFILLER_0_36_11 VGND VGND VPWR VPWR sky130_fd_sc_hd__fill_2
Xu_mem._0860_ u_mem.mem\[1\]\[3\] net4 u_mem._0423_ VGND VGND VPWR VPWR u_mem._0427_
+ sky130_fd_sc_hd__mux2_1
Xu_mem._0791_ u_mem.mem\[8\]\[5\] u_mem.mem\[9\]\[5\] u_mem._0248_ VGND VGND VPWR
+ VPWR u_mem._0364_ sky130_fd_sc_hd__mux2_1
Xinput7 din[6] VGND VGND VPWR VPWR net7 sky130_fd_sc_hd__clkbuf_2
XTAP_96 VGND VPWR sky130_fd_sc_hd__tapvpwrvgnd_1
Xu_mem._0989_ wr_clk u_mem._0017_ VGND VGND VPWR VPWR u_mem.mem\[12\]\[1\] sky130_fd_sc_hd__dfxtp_1
XFILLER_0_9_173 VGND VGND VPWR VPWR sky130_fd_sc_hd__fill_1
Xu_read._85_ u_read._31_ u_read._35_ u_read._20_ VGND VGND VPWR VPWR u_read._42_ sky130_fd_sc_hd__o21ai_1
X_3_ u_mem.dout\[3\] VGND VGND VPWR VPWR net15 sky130_fd_sc_hd__clkbuf_1
XPHY_91 VGND VGND VPWR VPWR sky130_fd_sc_hd__decap_3
XPHY_80 VGND VGND VPWR VPWR sky130_fd_sc_hd__decap_3
XFILLER_0_36_260 VGND VGND VPWR VPWR sky130_fd_sc_hd__decap_6
XFILLER_0_28_238 VPWR VGND VPWR VGND sky130_ef_sc_hd__decap_12
XFILLER_0_11_105 VGND VGND VPWR VPWR sky130_fd_sc_hd__decap_6
XFILLER_0_11_149 VPWR VGND VPWR VGND sky130_ef_sc_hd__decap_12
Xu_mem._0912_ u_mem._0454_ VGND VGND VPWR VPWR u_mem._0107_ sky130_fd_sc_hd__clkbuf_1
Xu_mem._0774_ u_mem.mem\[6\]\[4\] u_mem.mem\[7\]\[4\] u_mem._0237_ VGND VGND VPWR
+ VPWR u_mem._0348_ sky130_fd_sc_hd__mux2_1
Xu_mem._0843_ u_mem.mem\[5\]\[7\] u_mem._0243_ VGND VGND VPWR VPWR u_mem._0414_ sky130_fd_sc_hd__and2b_1
XFILLER_0_19_216 VGND VGND VPWR VPWR sky130_fd_sc_hd__decap_4
Xu_sync_wr2rd._31_ u_sync_wr2rd._15_ VGND VGND VPWR VPWR u_sync_wr2rd._05_ sky130_fd_sc_hd__clkbuf_1
XFILLER_0_6_110 VGND VGND VPWR VPWR sky130_fd_sc_hd__decap_8
Xu_read._68_ u_mem.rd_addr\[2\] u_mem.rd_addr\[1\] u_mem.rd_addr\[0\] VGND VGND VPWR
+ VPWR u_read._30_ sky130_fd_sc_hd__and3_1
Xu_mem._0490_ u_mem.mem\[3\]\[0\] u_mem._0136_ u_mem._0139_ VGND VGND VPWR VPWR u_mem._0140_
+ sky130_fd_sc_hd__mux2_1
Xinput10 rst VGND VGND VPWR VPWR net10 sky130_fd_sc_hd__buf_8
Xu_mem._1042_ wr_clk u_mem._0070_ VGND VGND VPWR VPWR u_mem.mem\[11\]\[6\] sky130_fd_sc_hd__dfxtp_1
Xu_mem._0826_ u_mem._0251_ u_mem._0397_ u_mem._0254_ VGND VGND VPWR VPWR u_mem._0398_
+ sky130_fd_sc_hd__a21oi_1
Xu_mem._0757_ u_mem.mem\[0\]\[3\] u_mem.mem\[1\]\[3\] u_mem._0266_ VGND VGND VPWR
+ VPWR u_mem._0332_ sky130_fd_sc_hd__mux2_1
Xu_mem._0688_ u_mem.rd_addr\[0\] VGND VGND VPWR VPWR u_mem._0266_ sky130_fd_sc_hd__clkbuf_4
XFILLER_0_15_241 VPWR VGND VPWR VGND sky130_ef_sc_hd__decap_12
Xu_mem._0611_ u_mem._0209_ VGND VGND VPWR VPWR u_mem._0051_ sky130_fd_sc_hd__clkbuf_1
Xu_mem._0542_ u_mem._0147_ u_mem.mem\[12\]\[4\] u_mem._0167_ VGND VGND VPWR VPWR u_mem._0172_
+ sky130_fd_sc_hd__mux2_1
Xu_sync_rd2wr._42_ wr_clk u_sync_rd2wr._02_ VGND VGND VPWR VPWR u_sync_rd2wr.gray_sync2\[2\]
+ sky130_fd_sc_hd__dfxtp_1
XFILLER_0_8_77 VGND VGND VPWR VPWR sky130_fd_sc_hd__decap_4
XFILLER_0_8_22 VGND VGND VPWR VPWR sky130_fd_sc_hd__decap_3
Xu_mem._1025_ wr_clk u_mem._0053_ VGND VGND VPWR VPWR u_mem.mem\[7\]\[5\] sky130_fd_sc_hd__dfxtp_1
XFILLER_0_40_3 VPWR VGND VPWR VGND sky130_ef_sc_hd__decap_12
Xu_mem._0809_ u_mem._0269_ u_mem._0380_ VGND VGND VPWR VPWR u_mem._0381_ sky130_fd_sc_hd__nand2_1
XFILLER_0_38_141 VGND VGND VPWR VPWR sky130_fd_sc_hd__fill_1
XTAP_269 VGND VPWR sky130_fd_sc_hd__tapvpwrvgnd_1
XTAP_258 VGND VPWR sky130_fd_sc_hd__tapvpwrvgnd_1
XTAP_247 VGND VPWR sky130_fd_sc_hd__tapvpwrvgnd_1
XTAP_203 VGND VPWR sky130_fd_sc_hd__tapvpwrvgnd_1
XTAP_214 VGND VPWR sky130_fd_sc_hd__tapvpwrvgnd_1
XTAP_225 VGND VPWR sky130_fd_sc_hd__tapvpwrvgnd_1
XTAP_236 VGND VPWR sky130_fd_sc_hd__tapvpwrvgnd_1
Xu_mem._0525_ u_mem._0162_ VGND VGND VPWR VPWR u_mem._0012_ sky130_fd_sc_hd__clkbuf_1
Xu_sync_rd2wr._25_ u_sync_rd2wr._12_ VGND VGND VPWR VPWR u_sync_rd2wr._02_ sky130_fd_sc_hd__clkbuf_1
XFILLER_0_44_188 VGND VGND VPWR VPWR sky130_fd_sc_hd__decap_8
Xu_mem._1008_ wr_clk u_mem._0036_ VGND VGND VPWR VPWR u_mem.mem\[13\]\[4\] sky130_fd_sc_hd__dfxtp_1
XFILLER_0_35_166 VGND VGND VPWR VPWR sky130_fd_sc_hd__fill_2
XFILLER_0_35_111 VGND VGND VPWR VPWR sky130_fd_sc_hd__fill_1
XFILLER_0_25_57 VGND VGND VPWR VPWR sky130_fd_sc_hd__decap_4
XFILLER_0_41_169 VGND VGND VPWR VPWR sky130_fd_sc_hd__decap_4
Xu_mem._0508_ u_mem.mem\[3\]\[6\] u_mem._0151_ u_mem._0139_ VGND VGND VPWR VPWR u_mem._0152_
+ sky130_fd_sc_hd__mux2_1
Xu_write._50_ u_sync_rd2wr.gray_sync2\[2\] u_write._17_ VGND VGND VPWR VPWR u_write._18_
+ sky130_fd_sc_hd__xnor2_1
XFILLER_0_17_111 VGND VGND VPWR VPWR sky130_fd_sc_hd__fill_1
XFILLER_0_17_155 VPWR VGND VPWR VGND sky130_ef_sc_hd__decap_12
XFILLER_0_11_15 VGND VGND VPWR VPWR sky130_fd_sc_hd__fill_2
XFILLER_0_11_26 VGND VGND VPWR VPWR sky130_fd_sc_hd__fill_1
XFILLER_0_11_48 VGND VGND VPWR VPWR sky130_fd_sc_hd__decap_4
Xinput8 din[7] VGND VGND VPWR VPWR net8 sky130_fd_sc_hd__clkbuf_2
Xu_mem._0790_ u_mem._0235_ u_mem._0361_ u_mem._0362_ u_mem._0245_ VGND VGND VPWR VPWR
+ u_mem._0363_ sky130_fd_sc_hd__o31a_1
XFILLER_0_31_191 VGND VGND VPWR VPWR sky130_fd_sc_hd__fill_1
XTAP_97 VGND VPWR sky130_fd_sc_hd__tapvpwrvgnd_1
Xu_mem._0988_ wr_clk u_mem._0016_ VGND VGND VPWR VPWR u_mem.mem\[12\]\[0\] sky130_fd_sc_hd__dfxtp_1
XFILLER_0_37_228 VGND VGND VPWR VPWR sky130_fd_sc_hd__decap_6
Xu_read._84_ u_mem.rd_addr\[2\] u_read._20_ u_read._41_ u_read._22_ VGND VGND VPWR
+ VPWR u_read._07_ sky130_fd_sc_hd__o211a_1
X_2_ u_mem.dout\[2\] VGND VGND VPWR VPWR net14 sky130_fd_sc_hd__clkbuf_1
XPHY_81 VGND VGND VPWR VPWR sky130_fd_sc_hd__decap_3
XPHY_70 VGND VGND VPWR VPWR sky130_fd_sc_hd__decap_3
Xu_mem._0911_ u_mem.mem\[10\]\[3\] net4 u_mem._0450_ VGND VGND VPWR VPWR u_mem._0454_
+ sky130_fd_sc_hd__mux2_1
Xu_mem._0842_ u_mem._0241_ u_mem.mem\[4\]\[7\] VGND VGND VPWR VPWR u_mem._0413_ sky130_fd_sc_hd__nor2_1
Xu_mem._0773_ u_mem._0339_ u_mem._0342_ u_mem._0344_ u_mem._0346_ u_mem._0256_ VGND
+ VGND VPWR VPWR u_mem._0347_ sky130_fd_sc_hd__a221o_1
XFILLER_0_42_253 VPWR VGND VPWR VGND sky130_ef_sc_hd__decap_12
Xu_sync_wr2rd._30_ net10 u_sync_wr2rd.gray_in\[0\] VGND VGND VPWR VPWR u_sync_wr2rd._15_
+ sky130_fd_sc_hd__and2b_1
XFILLER_0_34_209 VGND VGND VPWR VPWR sky130_fd_sc_hd__decap_8
Xu_read._67_ u_read._29_ VGND VGND VPWR VPWR u_read._02_ sky130_fd_sc_hd__clkbuf_1
XFILLER_0_17_36 VGND VGND VPWR VPWR sky130_fd_sc_hd__fill_1
Xinput11 wr_en VGND VGND VPWR VPWR net11 sky130_fd_sc_hd__buf_1
XFILLER_0_3_169 VGND VGND VPWR VPWR sky130_fd_sc_hd__decap_6
XFILLER_0_3_158 VGND VGND VPWR VPWR sky130_fd_sc_hd__fill_1
Xu_mem._1041_ wr_clk u_mem._0069_ VGND VGND VPWR VPWR u_mem.mem\[11\]\[5\] sky130_fd_sc_hd__dfxtp_1
XFILLER_0_24_253 VPWR VGND VPWR VGND sky130_ef_sc_hd__decap_12
Xu_mem._0825_ u_mem.mem\[2\]\[6\] u_mem.mem\[3\]\[6\] u_mem._0270_ VGND VGND VPWR
+ VPWR u_mem._0397_ sky130_fd_sc_hd__mux2_1
Xu_mem._0756_ u_mem._0240_ u_mem._0329_ u_mem._0330_ u_mem._0263_ VGND VGND VPWR VPWR
+ u_mem._0331_ sky130_fd_sc_hd__o31a_1
Xu_mem._0687_ u_mem._0235_ VGND VGND VPWR VPWR u_mem._0265_ sky130_fd_sc_hd__buf_2
XFILLER_0_15_253 VGND VGND VPWR VPWR sky130_fd_sc_hd__decap_6
XFILLER_0_30_201 VPWR VGND VPWR VGND sky130_ef_sc_hd__decap_12
XFILLER_0_30_256 VGND VGND VPWR VPWR sky130_fd_sc_hd__decap_3
XFILLER_0_0_139 VGND VGND VPWR VPWR sky130_fd_sc_hd__fill_1
Xu_mem._0610_ u_mem.mem\[7\]\[3\] u_mem._0145_ u_mem._0205_ VGND VGND VPWR VPWR u_mem._0209_
+ sky130_fd_sc_hd__mux2_1
XFILLER_0_21_256 VGND VGND VPWR VPWR sky130_fd_sc_hd__decap_8
Xu_mem._0541_ u_mem._0171_ VGND VGND VPWR VPWR u_mem._0019_ sky130_fd_sc_hd__clkbuf_1
XFILLER_0_28_68 VGND VGND VPWR VPWR sky130_fd_sc_hd__decap_4
Xu_sync_rd2wr._41_ wr_clk u_sync_rd2wr._01_ VGND VGND VPWR VPWR u_sync_rd2wr.gray_sync2\[1\]
+ sky130_fd_sc_hd__dfxtp_1
Xu_mem._1024_ wr_clk u_mem._0052_ VGND VGND VPWR VPWR u_mem.mem\[7\]\[4\] sky130_fd_sc_hd__dfxtp_1
XFILLER_0_8_34 VGND VGND VPWR VPWR sky130_fd_sc_hd__fill_2
Xu_mem._0739_ u_mem._0307_ u_mem._0310_ u_mem._0312_ u_mem._0314_ u_mem.rd_addr\[3\]
+ VGND VGND VPWR VPWR u_mem._0315_ sky130_fd_sc_hd__a221o_1
Xu_mem._0808_ u_mem.mem\[14\]\[6\] u_mem.mem\[15\]\[6\] u_mem._0270_ VGND VGND VPWR
+ VPWR u_mem._0380_ sky130_fd_sc_hd__mux2_1
XFILLER_0_38_197 VGND VGND VPWR VPWR sky130_fd_sc_hd__decap_4
XFILLER_0_38_175 VGND VGND VPWR VPWR sky130_fd_sc_hd__decap_8
XFILLER_0_38_131 VGND VGND VPWR VPWR sky130_fd_sc_hd__decap_8
XFILLER_0_14_15 VGND VGND VPWR VPWR sky130_fd_sc_hd__fill_1
XTAP_259 VGND VPWR sky130_fd_sc_hd__tapvpwrvgnd_1
XTAP_248 VGND VPWR sky130_fd_sc_hd__tapvpwrvgnd_1
XTAP_204 VGND VPWR sky130_fd_sc_hd__tapvpwrvgnd_1
XTAP_215 VGND VPWR sky130_fd_sc_hd__tapvpwrvgnd_1
XTAP_226 VGND VPWR sky130_fd_sc_hd__tapvpwrvgnd_1
XTAP_237 VGND VPWR sky130_fd_sc_hd__tapvpwrvgnd_1
Xu_mem._0524_ u_mem.mem\[4\]\[4\] u_mem._0147_ u_mem._0157_ VGND VGND VPWR VPWR u_mem._0162_
+ sky130_fd_sc_hd__mux2_1
Xu_sync_rd2wr._24_ net10 u_sync_rd2wr.gray_sync1\[2\] VGND VGND VPWR VPWR u_sync_rd2wr._12_
+ sky130_fd_sc_hd__and2b_1
Xu_mem._1007_ wr_clk u_mem._0035_ VGND VGND VPWR VPWR u_mem.mem\[13\]\[3\] sky130_fd_sc_hd__dfxtp_1
XFILLER_0_4_253 VGND VGND VPWR VPWR sky130_fd_sc_hd__decap_6
XFILLER_0_35_134 VPWR VGND VPWR VGND sky130_ef_sc_hd__decap_12
XFILLER_0_41_79 VGND VGND VPWR VPWR sky130_fd_sc_hd__fill_1
XFILLER_0_26_156 VGND VGND VPWR VPWR sky130_fd_sc_hd__decap_3
XFILLER_0_41_159 VGND VGND VPWR VPWR sky130_fd_sc_hd__decap_6
XFILLER_0_1_201 VPWR VGND VPWR VGND sky130_ef_sc_hd__decap_12
XFILLER_0_5_57 VGND VGND VPWR VPWR sky130_fd_sc_hd__decap_6
Xu_mem._0507_ net7 VGND VGND VPWR VPWR u_mem._0151_ sky130_fd_sc_hd__buf_2
XFILLER_0_17_167 VGND VGND VPWR VPWR sky130_fd_sc_hd__fill_1
Xinput9 rd_en VGND VGND VPWR VPWR net9 sky130_fd_sc_hd__clkbuf_1
XTAP_98 VGND VPWR sky130_fd_sc_hd__tapvpwrvgnd_1
Xu_mem._0987_ wr_clk u_mem._0015_ VGND VGND VPWR VPWR u_mem.mem\[4\]\[7\] sky130_fd_sc_hd__dfxtp_1
XFILLER_0_37_218 VGND VGND VPWR VPWR sky130_fd_sc_hd__fill_2
Xu_read._83_ u_read._26_ u_read._30_ u_read._20_ VGND VGND VPWR VPWR u_read._41_ sky130_fd_sc_hd__o21ai_1
XFILLER_0_13_181 VPWR VGND VPWR VGND sky130_ef_sc_hd__decap_12
X_1_ u_mem.dout\[1\] VGND VGND VPWR VPWR net13 sky130_fd_sc_hd__clkbuf_1
XPHY_82 VGND VGND VPWR VPWR sky130_fd_sc_hd__decap_3
XPHY_71 VGND VGND VPWR VPWR sky130_fd_sc_hd__decap_3
XPHY_60 VGND VGND VPWR VPWR sky130_fd_sc_hd__decap_3
XFILLER_0_22_37 VGND VGND VPWR VPWR sky130_fd_sc_hd__decap_3
Xu_mem._0910_ u_mem._0453_ VGND VGND VPWR VPWR u_mem._0106_ sky130_fd_sc_hd__clkbuf_1
Xu_mem._0772_ u_mem._0251_ u_mem._0345_ u_mem._0263_ VGND VGND VPWR VPWR u_mem._0346_
+ sky130_fd_sc_hd__a21oi_1
Xu_mem._0841_ u_mem._0236_ u_mem._0411_ VGND VGND VPWR VPWR u_mem._0412_ sky130_fd_sc_hd__nand2_1
XFILLER_0_42_265 VGND VGND VPWR VPWR sky130_fd_sc_hd__decap_4
XFILLER_0_18_251 VGND VGND VPWR VPWR sky130_fd_sc_hd__fill_1
Xu_read._66_ u_read._22_ u_read._28_ VGND VGND VPWR VPWR u_read._29_ sky130_fd_sc_hd__and2_1
Xu_mem._1040_ wr_clk u_mem._0068_ VGND VGND VPWR VPWR u_mem.mem\[11\]\[4\] sky130_fd_sc_hd__dfxtp_1
XFILLER_0_24_243 VGND VGND VPWR VPWR sky130_fd_sc_hd__decap_8
XFILLER_0_24_265 VGND VGND VPWR VPWR sky130_fd_sc_hd__decap_4
Xu_mem._0755_ u_mem.mem\[5\]\[3\] u_mem._0243_ VGND VGND VPWR VPWR u_mem._0330_ sky130_fd_sc_hd__and2b_1
Xu_mem._0824_ u_mem._0265_ u_mem._0395_ VGND VGND VPWR VPWR u_mem._0396_ sky130_fd_sc_hd__or2b_1
Xu_mem._0686_ u_mem._0247_ u_mem._0261_ u_mem._0262_ u_mem._0263_ VGND VGND VPWR VPWR
+ u_mem._0264_ sky130_fd_sc_hd__o31a_1
XFILLER_0_30_213 VGND VGND VPWR VPWR sky130_fd_sc_hd__fill_2
Xu_read._49_ u_read.rd_ptr_bin\[4\] u_read.wr_gray_sync2\[4\] VGND VGND VPWR VPWR
+ u_read._15_ sky130_fd_sc_hd__or2b_1
Xu_mem._0540_ u_mem._0145_ u_mem.mem\[12\]\[3\] u_mem._0167_ VGND VGND VPWR VPWR u_mem._0171_
+ sky130_fd_sc_hd__mux2_1
Xu_sync_rd2wr._40_ wr_clk u_sync_rd2wr._00_ VGND VGND VPWR VPWR u_sync_rd2wr.gray_sync2\[0\]
+ sky130_fd_sc_hd__dfxtp_1
Xu_mem._1023_ wr_clk u_mem._0051_ VGND VGND VPWR VPWR u_mem.mem\[7\]\[3\] sky130_fd_sc_hd__dfxtp_1
Xu_mem._0738_ u_mem._0269_ u_mem._0313_ u_mem._0254_ VGND VGND VPWR VPWR u_mem._0314_
+ sky130_fd_sc_hd__a21oi_1
Xu_mem._0807_ u_mem._0234_ u_mem._0368_ u_mem._0378_ u_mem._0379_ VGND VGND VPWR VPWR
+ u_mem._0077_ sky130_fd_sc_hd__a31oi_1
Xu_mem._0669_ u_mem._0235_ VGND VGND VPWR VPWR u_mem._0247_ sky130_fd_sc_hd__buf_2
XFILLER_0_38_187 VGND VGND VPWR VPWR sky130_fd_sc_hd__decap_3
XTAP_205 VGND VPWR sky130_fd_sc_hd__tapvpwrvgnd_1
Xu_mem._0523_ u_mem._0161_ VGND VGND VPWR VPWR u_mem._0011_ sky130_fd_sc_hd__clkbuf_1
XTAP_216 VGND VPWR sky130_fd_sc_hd__tapvpwrvgnd_1
XTAP_227 VGND VPWR sky130_fd_sc_hd__tapvpwrvgnd_1
XTAP_238 VGND VPWR sky130_fd_sc_hd__tapvpwrvgnd_1
XTAP_249 VGND VPWR sky130_fd_sc_hd__tapvpwrvgnd_1
Xu_sync_rd2wr._23_ u_sync_rd2wr._11_ VGND VGND VPWR VPWR u_sync_rd2wr._01_ sky130_fd_sc_hd__clkbuf_1
XFILLER_0_29_110 VGND VGND VPWR VPWR sky130_fd_sc_hd__fill_2
Xu_mem._1006_ wr_clk u_mem._0034_ VGND VGND VPWR VPWR u_mem.mem\[13\]\[2\] sky130_fd_sc_hd__dfxtp_1
XFILLER_0_35_146 VGND VGND VPWR VPWR sky130_fd_sc_hd__decap_8
XFILLER_0_35_113 VPWR VGND VPWR VGND sky130_ef_sc_hd__decap_12
XFILLER_0_41_105 VGND VGND VPWR VPWR sky130_fd_sc_hd__decap_6
XFILLER_0_41_47 VGND VGND VPWR VPWR sky130_fd_sc_hd__decap_8
XFILLER_0_1_213 VGND VGND VPWR VPWR sky130_fd_sc_hd__decap_8
Xu_mem._0506_ u_mem._0150_ VGND VGND VPWR VPWR u_mem._0005_ sky130_fd_sc_hd__clkbuf_1
XFILLER_0_15_81 VPWR VGND VPWR VGND sky130_ef_sc_hd__decap_12
XFILLER_0_17_102 VGND VGND VPWR VPWR sky130_fd_sc_hd__decap_3
XFILLER_0_17_113 VPWR VGND VPWR VGND sky130_ef_sc_hd__decap_12
XFILLER_0_32_138 VGND VGND VPWR VPWR sky130_fd_sc_hd__fill_2
XFILLER_0_16_190 VGND VGND VPWR VPWR sky130_fd_sc_hd__decap_6
XTAP_99 VGND VPWR sky130_fd_sc_hd__tapvpwrvgnd_1
Xu_mem._0986_ wr_clk u_mem._0014_ VGND VGND VPWR VPWR u_mem.mem\[4\]\[6\] sky130_fd_sc_hd__dfxtp_1
Xu_read._82_ u_read._39_ u_read._40_ VGND VGND VPWR VPWR u_read._06_ sky130_fd_sc_hd__nor2_1
XFILLER_0_13_193 VGND VGND VPWR VPWR sky130_fd_sc_hd__decap_6
X_0_ u_mem.dout\[0\] VGND VGND VPWR VPWR net12 sky130_fd_sc_hd__clkbuf_1
XPHY_83 VGND VGND VPWR VPWR sky130_fd_sc_hd__decap_3
XPHY_72 VGND VGND VPWR VPWR sky130_fd_sc_hd__decap_3
XFILLER_0_22_27 VGND VGND VPWR VPWR sky130_fd_sc_hd__fill_1
XFILLER_0_22_49 VPWR VGND VPWR VGND sky130_ef_sc_hd__decap_12
XPHY_50 VGND VGND VPWR VPWR sky130_fd_sc_hd__decap_3
XPHY_61 VGND VGND VPWR VPWR sky130_fd_sc_hd__decap_3
Xu_mem._0771_ u_mem.mem\[10\]\[4\] u_mem.mem\[11\]\[4\] u_mem._0252_ VGND VGND VPWR
+ VPWR u_mem._0345_ sky130_fd_sc_hd__mux2_1
Xu_mem._0840_ u_mem.mem\[6\]\[7\] u_mem.mem\[7\]\[7\] u_mem._0237_ VGND VGND VPWR
+ VPWR u_mem._0411_ sky130_fd_sc_hd__mux2_1
XFILLER_0_2_15 VPWR VGND VPWR VGND sky130_ef_sc_hd__decap_12
XFILLER_0_10_141 VPWR VGND VPWR VGND sky130_ef_sc_hd__decap_12
Xu_mem._0969_ u_mem._0484_ VGND VGND VPWR VPWR u_mem._0134_ sky130_fd_sc_hd__clkbuf_1
Xu_read._65_ u_read.rd_ptr_gray\[2\] u_read._27_ u_read._19_ VGND VGND VPWR VPWR u_read._28_
+ sky130_fd_sc_hd__mux2_1
XFILLER_0_24_211 VGND VGND VPWR VPWR sky130_fd_sc_hd__decap_8
Xu_mem._0754_ u_mem._0241_ u_mem.mem\[4\]\[3\] VGND VGND VPWR VPWR u_mem._0329_ sky130_fd_sc_hd__nor2_1
Xu_mem._0685_ u_mem.rd_addr\[2\] VGND VGND VPWR VPWR u_mem._0263_ sky130_fd_sc_hd__clkbuf_4
Xu_mem._0823_ u_mem.mem\[0\]\[6\] u_mem.mem\[1\]\[6\] u_mem._0248_ VGND VGND VPWR
+ VPWR u_mem._0395_ sky130_fd_sc_hd__mux2_1
XFILLER_0_15_222 VGND VGND VPWR VPWR sky130_fd_sc_hd__fill_2
Xu_mem._1099_ wr_clk u_mem._0127_ VGND VGND VPWR VPWR u_mem.mem\[5\]\[7\] sky130_fd_sc_hd__dfxtp_1
Xu_read._48_ u_read.rd_ptr_gray\[0\] u_read._10_ u_read._11_ u_read._12_ u_read._13_
+ VGND VGND VPWR VPWR u_read._14_ sky130_fd_sc_hd__a2111o_1
Xu_mem._1022_ wr_clk u_mem._0050_ VGND VGND VPWR VPWR u_mem.mem\[7\]\[2\] sky130_fd_sc_hd__dfxtp_1
XFILLER_0_12_269 VGND VGND VPWR VPWR sky130_fd_sc_hd__fill_1
Xu_mem._0737_ u_mem.mem\[2\]\[2\] u_mem.mem\[3\]\[2\] u_mem._0270_ VGND VGND VPWR
+ VPWR u_mem._0313_ sky130_fd_sc_hd__mux2_1
Xu_mem._0668_ u_mem._0240_ u_mem._0242_ u_mem._0244_ u_mem._0245_ VGND VGND VPWR VPWR
+ u_mem._0246_ sky130_fd_sc_hd__o31a_1
Xu_mem._0806_ u_mem.dout\[5\] u_mem._0233_ VGND VGND VPWR VPWR u_mem._0379_ sky130_fd_sc_hd__nor2_1
Xu_mem._0599_ u_mem.mem\[2\]\[6\] u_mem._0151_ u_mem._0196_ VGND VGND VPWR VPWR u_mem._0203_
+ sky130_fd_sc_hd__mux2_1
XFILLER_0_30_38 VPWR VGND VPWR VGND sky130_ef_sc_hd__decap_12
XTAP_206 VGND VPWR sky130_fd_sc_hd__tapvpwrvgnd_1
XTAP_217 VGND VPWR sky130_fd_sc_hd__tapvpwrvgnd_1
XTAP_228 VGND VPWR sky130_fd_sc_hd__tapvpwrvgnd_1
XTAP_239 VGND VPWR sky130_fd_sc_hd__tapvpwrvgnd_1
Xu_mem._0522_ u_mem.mem\[4\]\[3\] u_mem._0145_ u_mem._0157_ VGND VGND VPWR VPWR u_mem._0161_
+ sky130_fd_sc_hd__mux2_1
XFILLER_0_44_103 VGND VGND VPWR VPWR sky130_fd_sc_hd__decap_4
Xu_sync_rd2wr._22_ net10 u_sync_rd2wr.gray_sync1\[1\] VGND VGND VPWR VPWR u_sync_rd2wr._11_
+ sky130_fd_sc_hd__and2b_1
XFILLER_0_29_100 VGND VGND VPWR VPWR sky130_fd_sc_hd__fill_2
XFILLER_0_44_125 VGND VGND VPWR VPWR sky130_fd_sc_hd__decap_3
XFILLER_0_4_200 VGND VGND VPWR VPWR sky130_fd_sc_hd__decap_8
Xu_mem._1005_ wr_clk u_mem._0033_ VGND VGND VPWR VPWR u_mem.mem\[13\]\[1\] sky130_fd_sc_hd__dfxtp_1
XFILLER_0_35_169 VPWR VGND VPWR VGND sky130_ef_sc_hd__decap_12
XFILLER_0_0_81 VGND VGND VPWR VPWR sky130_fd_sc_hd__decap_3
XFILLER_0_41_15 VPWR VGND VPWR VGND sky130_ef_sc_hd__decap_12
XFILLER_0_1_225 VPWR VGND VPWR VGND sky130_ef_sc_hd__decap_12
XFILLER_0_5_15 VPWR VGND VPWR VGND sky130_ef_sc_hd__decap_12
Xu_mem._0505_ u_mem.mem\[3\]\[5\] u_mem._0149_ u_mem._0139_ VGND VGND VPWR VPWR u_mem._0150_
+ sky130_fd_sc_hd__mux2_1
XFILLER_0_15_93 VPWR VGND VPWR VGND sky130_ef_sc_hd__decap_12
XFILLER_0_17_125 VGND VGND VPWR VPWR sky130_fd_sc_hd__decap_4
XFILLER_0_17_169 VPWR VGND VPWR VGND sky130_ef_sc_hd__decap_12
XFILLER_0_31_81 VGND VGND VPWR VPWR sky130_fd_sc_hd__fill_2
XFILLER_0_23_106 VGND VGND VPWR VPWR sky130_fd_sc_hd__decap_6
XFILLER_0_14_106 VGND VGND VPWR VPWR sky130_fd_sc_hd__decap_6
XFILLER_0_22_150 VGND VGND VPWR VPWR sky130_fd_sc_hd__fill_1
XFILLER_0_22_161 VGND VGND VPWR VPWR sky130_fd_sc_hd__fill_1
Xu_mem._0985_ wr_clk u_mem._0013_ VGND VGND VPWR VPWR u_mem.mem\[4\]\[5\] sky130_fd_sc_hd__dfxtp_1
XFILLER_0_9_111 VGND VGND VPWR VPWR sky130_fd_sc_hd__fill_1
XFILLER_0_9_122 VGND VGND VPWR VPWR sky130_fd_sc_hd__decap_3
XFILLER_0_26_81 VGND VGND VPWR VPWR sky130_fd_sc_hd__decap_3
XFILLER_0_45_264 VGND VGND VPWR VPWR sky130_fd_sc_hd__decap_3
Xu_read._81_ u_mem.rd_addr\[1\] u_mem.rd_addr\[0\] u_read._19_ net10 VGND VGND VPWR
+ VPWR u_read._40_ sky130_fd_sc_hd__a31o_1
XFILLER_0_9_199 VPWR VGND VPWR VGND sky130_ef_sc_hd__decap_12
XFILLER_0_13_172 VGND VGND VPWR VPWR sky130_fd_sc_hd__decap_6
XPHY_84 VGND VGND VPWR VPWR sky130_fd_sc_hd__decap_3
XPHY_73 VGND VGND VPWR VPWR sky130_fd_sc_hd__decap_3
XPHY_40 VGND VGND VPWR VPWR sky130_fd_sc_hd__decap_3
XPHY_51 VGND VGND VPWR VPWR sky130_fd_sc_hd__decap_3
XPHY_62 VGND VGND VPWR VPWR sky130_fd_sc_hd__decap_3
Xu_mem._0770_ u_mem._0247_ u_mem._0343_ VGND VGND VPWR VPWR u_mem._0344_ sky130_fd_sc_hd__or2b_1
XFILLER_0_2_27 VGND VGND VPWR VPWR sky130_fd_sc_hd__fill_1
XFILLER_0_10_153 VGND VGND VPWR VPWR sky130_fd_sc_hd__decap_6
XFILLER_0_10_175 VGND VGND VPWR VPWR sky130_fd_sc_hd__decap_3
Xu_mem._0968_ u_mem.mem\[9\]\[6\] net7 u_mem._0477_ VGND VGND VPWR VPWR u_mem._0484_
+ sky130_fd_sc_hd__mux2_1
XFILLER_0_10_197 VGND VGND VPWR VPWR sky130_fd_sc_hd__fill_2
Xu_mem._0899_ u_mem._0447_ VGND VGND VPWR VPWR u_mem._0101_ sky130_fd_sc_hd__clkbuf_1
XFILLER_0_18_253 VPWR VGND VPWR VGND sky130_ef_sc_hd__decap_12
Xu_read._64_ u_mem.rd_addr\[3\] u_read._26_ VGND VGND VPWR VPWR u_read._27_ sky130_fd_sc_hd__xnor2_1
XFILLER_0_5_191 VGND VGND VPWR VPWR sky130_fd_sc_hd__decap_3
XFILLER_0_24_201 VGND VGND VPWR VPWR sky130_fd_sc_hd__fill_1
Xu_mem._0822_ u_mem._0240_ u_mem._0392_ u_mem._0393_ u_mem._0245_ VGND VGND VPWR VPWR
+ u_mem._0394_ sky130_fd_sc_hd__o31a_1
Xu_mem._0684_ u_mem.mem\[5\]\[0\] u_mem._0252_ VGND VGND VPWR VPWR u_mem._0262_ sky130_fd_sc_hd__and2b_1
Xu_mem._0753_ u_mem._0236_ u_mem._0327_ VGND VGND VPWR VPWR u_mem._0328_ sky130_fd_sc_hd__nand2_1
XFILLER_0_23_82 VPWR VGND VPWR VGND sky130_ef_sc_hd__decap_12
Xu_mem._1098_ wr_clk u_mem._0126_ VGND VGND VPWR VPWR u_mem.mem\[5\]\[6\] sky130_fd_sc_hd__dfxtp_1
Xu_read._47_ u_read.rd_ptr_gray\[2\] u_read.wr_gray_sync2\[2\] VGND VGND VPWR VPWR
+ u_read._13_ sky130_fd_sc_hd__and2b_1
XFILLER_0_0_109 VGND VGND VPWR VPWR sky130_fd_sc_hd__decap_3
XFILLER_0_44_15 VPWR VGND VPWR VGND sky130_ef_sc_hd__decap_12
XFILLER_0_28_38 VGND VGND VPWR VPWR sky130_fd_sc_hd__decap_8
Xu_mem._1021_ wr_clk u_mem._0049_ VGND VGND VPWR VPWR u_mem.mem\[7\]\[1\] sky130_fd_sc_hd__dfxtp_1
Xu_mem._0805_ u_mem._0370_ u_mem._0373_ u_mem._0375_ u_mem._0377_ u_mem.rd_addr\[3\]
+ VGND VGND VPWR VPWR u_mem._0378_ sky130_fd_sc_hd__a221o_1
Xu_mem._0736_ u_mem._0265_ u_mem._0311_ VGND VGND VPWR VPWR u_mem._0312_ sky130_fd_sc_hd__or2b_1
Xu_mem._0598_ u_mem._0202_ VGND VGND VPWR VPWR u_mem._0045_ sky130_fd_sc_hd__clkbuf_1
Xu_mem._0667_ u_mem.rd_addr\[2\] VGND VGND VPWR VPWR u_mem._0245_ sky130_fd_sc_hd__clkbuf_4
XTAP_207 VGND VPWR sky130_fd_sc_hd__tapvpwrvgnd_1
XTAP_218 VGND VPWR sky130_fd_sc_hd__tapvpwrvgnd_1
XTAP_229 VGND VPWR sky130_fd_sc_hd__tapvpwrvgnd_1
Xu_mem._0521_ u_mem._0160_ VGND VGND VPWR VPWR u_mem._0010_ sky130_fd_sc_hd__clkbuf_1
Xu_sync_rd2wr._21_ u_sync_rd2wr._10_ VGND VGND VPWR VPWR u_sync_rd2wr._00_ sky130_fd_sc_hd__clkbuf_1
Xu_mem._1004_ wr_clk u_mem._0032_ VGND VGND VPWR VPWR u_mem.mem\[13\]\[0\] sky130_fd_sc_hd__dfxtp_1
XFILLER_0_29_123 VGND VGND VPWR VPWR sky130_fd_sc_hd__fill_1
XFILLER_0_29_178 VPWR VGND VPWR VGND sky130_ef_sc_hd__decap_12
Xu_mem._0719_ u_mem._0234_ u_mem._0284_ u_mem._0294_ u_mem._0295_ VGND VGND VPWR VPWR
+ u_mem._0073_ sky130_fd_sc_hd__a31oi_1
XFILLER_0_29_92 VGND VGND VPWR VPWR sky130_fd_sc_hd__decap_8
XFILLER_0_31_3 VGND VGND VPWR VPWR sky130_fd_sc_hd__decap_6
XFILLER_0_9_91 VGND VGND VPWR VPWR sky130_fd_sc_hd__fill_1
XFILLER_0_41_27 VPWR VGND VPWR VGND sky130_ef_sc_hd__decap_12
XFILLER_0_26_115 VPWR VGND VPWR VGND sky130_ef_sc_hd__decap_12
XFILLER_0_1_237 VPWR VGND VPWR VGND sky130_ef_sc_hd__decap_12
XFILLER_0_26_148 VGND VGND VPWR VPWR sky130_fd_sc_hd__decap_8
XFILLER_0_5_27 VPWR VGND VPWR VGND sky130_ef_sc_hd__decap_12
Xu_mem._0504_ net6 VGND VGND VPWR VPWR u_mem._0149_ sky130_fd_sc_hd__buf_2
XFILLER_0_32_118 VGND VGND VPWR VPWR sky130_fd_sc_hd__fill_1
XFILLER_0_40_195 VGND VGND VPWR VPWR sky130_fd_sc_hd__fill_1
XFILLER_0_25_181 VPWR VGND VPWR VGND sky130_ef_sc_hd__decap_12
XFILLER_0_36_38 VPWR VGND VPWR VGND sky130_ef_sc_hd__decap_12
Xu_mem._0984_ wr_clk u_mem._0012_ VGND VGND VPWR VPWR u_mem.mem\[4\]\[4\] sky130_fd_sc_hd__dfxtp_1
XFILLER_0_45_221 VGND VGND VPWR VPWR sky130_fd_sc_hd__decap_3
Xu_read._80_ u_mem.rd_addr\[0\] u_read._19_ u_mem.rd_addr\[1\] VGND VGND VPWR VPWR
+ u_read._39_ sky130_fd_sc_hd__a21oi_1
XPHY_30 VGND VGND VPWR VPWR sky130_fd_sc_hd__decap_3
XPHY_85 VGND VGND VPWR VPWR sky130_fd_sc_hd__decap_3
XPHY_74 VGND VGND VPWR VPWR sky130_fd_sc_hd__decap_3
XPHY_41 VGND VGND VPWR VPWR sky130_fd_sc_hd__decap_3
XFILLER_0_22_29 VGND VGND VPWR VPWR sky130_fd_sc_hd__decap_8
XPHY_52 VGND VGND VPWR VPWR sky130_fd_sc_hd__decap_3
XPHY_63 VGND VGND VPWR VPWR sky130_fd_sc_hd__decap_3
Xu_write._89_ wr_clk u_write._06_ VGND VGND VPWR VPWR u_mem.wr_addr\[1\] sky130_fd_sc_hd__dfxtp_4
XFILLER_0_27_210 VGND VGND VPWR VPWR sky130_fd_sc_hd__decap_8
XFILLER_0_27_221 VGND VGND VPWR VPWR sky130_fd_sc_hd__decap_3
XFILLER_0_10_187 VGND VGND VPWR VPWR sky130_fd_sc_hd__fill_1
Xu_mem._0967_ u_mem._0483_ VGND VGND VPWR VPWR u_mem._0133_ sky130_fd_sc_hd__clkbuf_1
Xu_mem._0898_ u_mem._0149_ u_mem.mem\[15\]\[5\] u_mem._0441_ VGND VGND VPWR VPWR u_mem._0447_
+ sky130_fd_sc_hd__mux2_1
XFILLER_0_37_81 VPWR VGND VPWR VGND sky130_ef_sc_hd__decap_12
XFILLER_0_18_265 VGND VGND VPWR VPWR sky130_fd_sc_hd__decap_4
XFILLER_0_33_257 VGND VGND VPWR VPWR sky130_fd_sc_hd__fill_2
Xu_read._63_ u_mem.rd_addr\[1\] u_mem.rd_addr\[0\] u_mem.rd_addr\[2\] VGND VGND VPWR
+ VPWR u_read._26_ sky130_fd_sc_hd__a21oi_1
Xu_mem._0752_ u_mem.mem\[6\]\[3\] u_mem.mem\[7\]\[3\] u_mem._0258_ VGND VGND VPWR
+ VPWR u_mem._0327_ sky130_fd_sc_hd__mux2_1
Xu_mem._0821_ u_mem.mem\[5\]\[6\] u_mem._0243_ VGND VGND VPWR VPWR u_mem._0393_ sky130_fd_sc_hd__and2b_1
Xu_mem._0683_ u_mem._0241_ u_mem.mem\[4\]\[0\] VGND VGND VPWR VPWR u_mem._0261_ sky130_fd_sc_hd__nor2_1
XFILLER_0_23_94 VPWR VGND VPWR VGND sky130_ef_sc_hd__decap_12
Xu_mem._1097_ wr_clk u_mem._0125_ VGND VGND VPWR VPWR u_mem.mem\[5\]\[5\] sky130_fd_sc_hd__dfxtp_1
XFILLER_0_3_93 VGND VGND VPWR VPWR sky130_fd_sc_hd__decap_4
Xu_read._46_ u_read.rd_ptr_gray\[1\] u_read.wr_gray_sync2\[1\] VGND VGND VPWR VPWR
+ u_read._12_ sky130_fd_sc_hd__and2b_1
XFILLER_0_44_27 VGND VGND VPWR VPWR sky130_fd_sc_hd__fill_1
Xu_mem._1020_ wr_clk u_mem._0048_ VGND VGND VPWR VPWR u_mem.mem\[7\]\[0\] sky130_fd_sc_hd__dfxtp_1
XFILLER_0_12_216 VGND VGND VPWR VPWR sky130_fd_sc_hd__fill_1
Xu_mem._0735_ u_mem.mem\[0\]\[2\] u_mem.mem\[1\]\[2\] u_mem._0266_ VGND VGND VPWR
+ VPWR u_mem._0311_ sky130_fd_sc_hd__mux2_1
Xu_mem._0804_ u_mem._0251_ u_mem._0376_ u_mem._0254_ VGND VGND VPWR VPWR u_mem._0377_
+ sky130_fd_sc_hd__a21oi_1
XFILLER_0_33_7 VPWR VGND VPWR VGND sky130_ef_sc_hd__decap_12
Xu_mem._0666_ u_mem.mem\[13\]\[0\] u_mem._0243_ VGND VGND VPWR VPWR u_mem._0244_ sky130_fd_sc_hd__and2b_1
XFILLER_0_18_83 VGND VGND VPWR VPWR sky130_fd_sc_hd__fill_1
XFILLER_0_18_94 VPWR VGND VPWR VGND sky130_ef_sc_hd__decap_12
Xu_mem._0597_ u_mem.mem\[2\]\[5\] u_mem._0149_ u_mem._0196_ VGND VGND VPWR VPWR u_mem._0202_
+ sky130_fd_sc_hd__mux2_1
XFILLER_0_39_27 VGND VGND VPWR VPWR sky130_fd_sc_hd__fill_1
XTAP_208 VGND VPWR sky130_fd_sc_hd__tapvpwrvgnd_1
XTAP_219 VGND VPWR sky130_fd_sc_hd__tapvpwrvgnd_1
Xu_mem._0520_ u_mem.mem\[4\]\[2\] u_mem._0143_ u_mem._0157_ VGND VGND VPWR VPWR u_mem._0160_
+ sky130_fd_sc_hd__mux2_1
Xu_sync_rd2wr._20_ net10 u_sync_rd2wr.gray_sync1\[0\] VGND VGND VPWR VPWR u_sync_rd2wr._10_
+ sky130_fd_sc_hd__and2b_1
Xu_mem._1003_ wr_clk u_mem._0031_ VGND VGND VPWR VPWR u_mem.mem\[8\]\[7\] sky130_fd_sc_hd__dfxtp_1
Xu_mem._0718_ u_mem.dout\[1\] u_mem._0234_ VGND VGND VPWR VPWR u_mem._0295_ sky130_fd_sc_hd__nor2_1
XFILLER_0_24_3 VGND VGND VPWR VPWR sky130_fd_sc_hd__decap_4
Xu_mem._0649_ u_mem._0229_ VGND VGND VPWR VPWR u_mem._0069_ sky130_fd_sc_hd__clkbuf_1
XFILLER_0_41_39 VGND VGND VPWR VPWR sky130_fd_sc_hd__fill_2
XFILLER_0_26_127 VPWR VGND VPWR VGND sky130_ef_sc_hd__decap_12
XFILLER_0_1_249 VPWR VGND VPWR VGND sky130_ef_sc_hd__decap_12
XFILLER_0_5_39 VPWR VGND VPWR VGND sky130_ef_sc_hd__decap_12
Xu_mem._0503_ u_mem._0148_ VGND VGND VPWR VPWR u_mem._0004_ sky130_fd_sc_hd__clkbuf_1
XFILLER_0_15_51 VGND VGND VPWR VPWR sky130_fd_sc_hd__decap_4
XFILLER_0_25_193 VPWR VGND VPWR VGND sky130_ef_sc_hd__decap_12
XFILLER_0_31_61 VGND VGND VPWR VPWR sky130_fd_sc_hd__fill_2
XFILLER_0_40_141 VGND VGND VPWR VPWR sky130_fd_sc_hd__decap_8
Xu_mem._0983_ wr_clk u_mem._0011_ VGND VGND VPWR VPWR u_mem.mem\[4\]\[3\] sky130_fd_sc_hd__dfxtp_1
XFILLER_0_26_61 VGND VGND VPWR VPWR sky130_fd_sc_hd__fill_2
XFILLER_0_26_72 VGND VGND VPWR VPWR sky130_fd_sc_hd__decap_6
XPHY_20 VGND VGND VPWR VPWR sky130_fd_sc_hd__decap_3
XPHY_31 VGND VGND VPWR VPWR sky130_fd_sc_hd__decap_3
XPHY_42 VGND VGND VPWR VPWR sky130_fd_sc_hd__decap_3
XPHY_53 VGND VGND VPWR VPWR sky130_fd_sc_hd__decap_3
XPHY_64 VGND VGND VPWR VPWR sky130_fd_sc_hd__decap_3
XPHY_86 VGND VGND VPWR VPWR sky130_fd_sc_hd__decap_3
XPHY_75 VGND VGND VPWR VPWR sky130_fd_sc_hd__decap_3
XFILLER_0_36_266 VGND VGND VPWR VPWR sky130_fd_sc_hd__fill_1
Xu_write._88_ wr_clk u_write._05_ VGND VGND VPWR VPWR u_mem.wr_addr\[0\] sky130_fd_sc_hd__dfxtp_4
XFILLER_0_2_29 VPWR VGND VPWR VGND sky130_ef_sc_hd__decap_12
XFILLER_0_42_269 VGND VGND VPWR VPWR sky130_fd_sc_hd__fill_1
XFILLER_0_6_149 VPWR VGND VPWR VGND sky130_ef_sc_hd__decap_12
XFILLER_0_12_85 VGND VGND VPWR VPWR sky130_fd_sc_hd__fill_2
Xu_mem._0897_ u_mem._0446_ VGND VGND VPWR VPWR u_mem._0100_ sky130_fd_sc_hd__clkbuf_1
Xu_mem._0966_ u_mem.mem\[9\]\[5\] net6 u_mem._0477_ VGND VGND VPWR VPWR u_mem._0483_
+ sky130_fd_sc_hd__mux2_1
XFILLER_0_33_225 VPWR VGND VPWR VGND sky130_ef_sc_hd__decap_12
Xu_read._62_ u_read.rd_ptr_gray\[1\] u_read._20_ u_read._25_ VGND VGND VPWR VPWR u_read._01_
+ sky130_fd_sc_hd__o21ba_1
XFILLER_0_24_269 VGND VGND VPWR VPWR sky130_fd_sc_hd__fill_1
Xu_mem._0751_ u_mem._0318_ u_mem._0321_ u_mem._0323_ u_mem._0325_ u_mem._0256_ VGND
+ VGND VPWR VPWR u_mem._0326_ sky130_fd_sc_hd__a221o_1
Xu_mem._0682_ u_mem._0236_ u_mem._0259_ VGND VGND VPWR VPWR u_mem._0260_ sky130_fd_sc_hd__nand2_1
Xu_mem._0820_ u_mem._0241_ u_mem.mem\[4\]\[6\] VGND VGND VPWR VPWR u_mem._0392_ sky130_fd_sc_hd__nor2_1
Xu_mem._1096_ wr_clk u_mem._0124_ VGND VGND VPWR VPWR u_mem.mem\[5\]\[4\] sky130_fd_sc_hd__dfxtp_1
Xu_mem._0949_ u_mem.mem\[5\]\[5\] net6 u_mem._0468_ VGND VGND VPWR VPWR u_mem._0474_
+ sky130_fd_sc_hd__mux2_1
Xu_read._45_ u_read.wr_gray_sync2\[4\] u_read.rd_ptr_bin\[4\] VGND VGND VPWR VPWR
+ u_read._11_ sky130_fd_sc_hd__and2b_1
XFILLER_0_21_239 VGND VGND VPWR VPWR sky130_fd_sc_hd__fill_1
XFILLER_0_20_250 VGND VGND VPWR VPWR sky130_fd_sc_hd__fill_2
Xu_mem._0734_ u_mem._0240_ u_mem._0308_ u_mem._0309_ u_mem._0263_ VGND VGND VPWR VPWR
+ u_mem._0310_ sky130_fd_sc_hd__o31a_1
Xu_mem._0803_ u_mem.mem\[2\]\[5\] u_mem.mem\[3\]\[5\] u_mem._0270_ VGND VGND VPWR
+ VPWR u_mem._0376_ sky130_fd_sc_hd__mux2_1
XFILLER_0_26_7 VGND VGND VPWR VPWR sky130_fd_sc_hd__decap_3
Xu_mem._0665_ u_mem.rd_addr\[0\] VGND VGND VPWR VPWR u_mem._0243_ sky130_fd_sc_hd__buf_2
Xu_mem._0596_ u_mem._0201_ VGND VGND VPWR VPWR u_mem._0044_ sky130_fd_sc_hd__clkbuf_1
XFILLER_0_34_83 VGND VGND VPWR VPWR sky130_fd_sc_hd__fill_1
Xu_mem._1079_ wr_clk u_mem._0107_ VGND VGND VPWR VPWR u_mem.mem\[10\]\[3\] sky130_fd_sc_hd__dfxtp_1
XTAP_209 VGND VPWR sky130_fd_sc_hd__tapvpwrvgnd_1
XFILLER_0_44_139 VGND VGND VPWR VPWR sky130_fd_sc_hd__fill_1
Xu_mem._1002_ wr_clk u_mem._0030_ VGND VGND VPWR VPWR u_mem.mem\[8\]\[6\] sky130_fd_sc_hd__dfxtp_1
XFILLER_0_29_61 VGND VGND VPWR VPWR sky130_fd_sc_hd__decap_3
XFILLER_0_45_82 VGND VGND VPWR VPWR sky130_fd_sc_hd__fill_2
Xu_mem._0717_ u_mem._0286_ u_mem._0289_ u_mem._0291_ u_mem._0293_ u_mem.rd_addr\[3\]
+ VGND VGND VPWR VPWR u_mem._0294_ sky130_fd_sc_hd__a221o_1
XFILLER_0_17_3 VGND VGND VPWR VPWR sky130_fd_sc_hd__fill_1
Xu_mem._0648_ u_mem.mem\[11\]\[5\] net6 u_mem._0223_ VGND VGND VPWR VPWR u_mem._0229_
+ sky130_fd_sc_hd__mux2_1
Xu_mem._0579_ u_mem._0149_ u_mem.mem\[13\]\[5\] u_mem._0186_ VGND VGND VPWR VPWR u_mem._0192_
+ sky130_fd_sc_hd__mux2_1
XFILLER_0_43_172 VGND VGND VPWR VPWR sky130_fd_sc_hd__fill_1
XFILLER_0_26_139 VGND VGND VPWR VPWR sky130_fd_sc_hd__fill_1
XFILLER_0_34_183 VPWR VGND VPWR VGND sky130_ef_sc_hd__decap_12
Xu_mem._0502_ u_mem.mem\[3\]\[4\] u_mem._0147_ u_mem._0139_ VGND VGND VPWR VPWR u_mem._0148_
+ sky130_fd_sc_hd__mux2_1
Xu_mem._0982_ wr_clk u_mem._0010_ VGND VGND VPWR VPWR u_mem.mem\[4\]\[2\] sky130_fd_sc_hd__dfxtp_1
XFILLER_0_45_256 VGND VGND VPWR VPWR sky130_fd_sc_hd__decap_8
XFILLER_0_9_169 VGND VGND VPWR VPWR sky130_fd_sc_hd__decap_4
XFILLER_0_13_120 VGND VGND VPWR VPWR sky130_fd_sc_hd__fill_1
XFILLER_0_13_131 VGND VGND VPWR VPWR sky130_fd_sc_hd__fill_1
XPHY_87 VGND VGND VPWR VPWR sky130_fd_sc_hd__decap_3
XPHY_76 VGND VGND VPWR VPWR sky130_fd_sc_hd__decap_3
XPHY_10 VGND VGND VPWR VPWR sky130_fd_sc_hd__decap_3
XPHY_21 VGND VGND VPWR VPWR sky130_fd_sc_hd__decap_3
XPHY_32 VGND VGND VPWR VPWR sky130_fd_sc_hd__decap_3
XPHY_43 VGND VGND VPWR VPWR sky130_fd_sc_hd__decap_3
XPHY_54 VGND VGND VPWR VPWR sky130_fd_sc_hd__decap_3
XPHY_65 VGND VGND VPWR VPWR sky130_fd_sc_hd__decap_3
Xu_write._87_ wr_clk u_write._04_ VGND VGND VPWR VPWR u_write.wr_ptr_bin\[4\] sky130_fd_sc_hd__dfxtp_1
XFILLER_0_27_234 VPWR VGND VPWR VGND sky130_ef_sc_hd__decap_12
Xu_mem._0896_ u_mem._0147_ u_mem.mem\[15\]\[4\] u_mem._0441_ VGND VGND VPWR VPWR u_mem._0446_
+ sky130_fd_sc_hd__mux2_1
Xu_mem._0965_ u_mem._0482_ VGND VGND VPWR VPWR u_mem._0132_ sky130_fd_sc_hd__clkbuf_1
Xu_read._61_ u_read._19_ u_read._23_ u_read._24_ net10 VGND VGND VPWR VPWR u_read._25_
+ sky130_fd_sc_hd__a31o_1
XFILLER_0_33_237 VPWR VGND VPWR VGND sky130_ef_sc_hd__decap_12
XFILLER_0_33_215 VGND VGND VPWR VPWR sky130_fd_sc_hd__decap_4
XFILLER_0_18_223 VGND VGND VPWR VPWR sky130_fd_sc_hd__decap_3
XFILLER_0_5_183 VGND VGND VPWR VPWR sky130_fd_sc_hd__decap_8
XFILLER_0_33_19 VGND VGND VPWR VPWR sky130_fd_sc_hd__fill_1
Xu_mem._0681_ u_mem.mem\[6\]\[0\] u_mem.mem\[7\]\[0\] u_mem._0258_ VGND VGND VPWR
+ VPWR u_mem._0259_ sky130_fd_sc_hd__mux2_1
Xu_mem._0750_ u_mem._0251_ u_mem._0324_ u_mem._0263_ VGND VGND VPWR VPWR u_mem._0325_
+ sky130_fd_sc_hd__a21oi_1
Xu_mem._1095_ wr_clk u_mem._0123_ VGND VGND VPWR VPWR u_mem.mem\[5\]\[3\] sky130_fd_sc_hd__dfxtp_1
XFILLER_0_2_197 VGND VGND VPWR VPWR sky130_fd_sc_hd__decap_6
Xu_mem._0948_ u_mem._0473_ VGND VGND VPWR VPWR u_mem._0124_ sky130_fd_sc_hd__clkbuf_1
XFILLER_0_3_51 VGND VGND VPWR VPWR sky130_fd_sc_hd__decap_4
Xu_mem._0879_ u_mem._0147_ u_mem.mem\[14\]\[4\] u_mem._0432_ VGND VGND VPWR VPWR u_mem._0437_
+ sky130_fd_sc_hd__mux2_1
Xu_read._44_ u_read.wr_gray_sync2\[0\] VGND VGND VPWR VPWR u_read._10_ sky130_fd_sc_hd__inv_2
XFILLER_0_44_29 VPWR VGND VPWR VGND sky130_ef_sc_hd__decap_12
XFILLER_0_8_29 VGND VGND VPWR VPWR sky130_fd_sc_hd__fill_2
XFILLER_0_20_262 VGND VGND VPWR VPWR sky130_fd_sc_hd__decap_8
Xu_mem._0802_ u_mem._0265_ u_mem._0374_ VGND VGND VPWR VPWR u_mem._0375_ sky130_fd_sc_hd__or2b_1
Xu_mem._0664_ u_mem._0241_ u_mem.mem\[12\]\[0\] VGND VGND VPWR VPWR u_mem._0242_ sky130_fd_sc_hd__nor2_1
Xu_mem._0733_ u_mem.mem\[5\]\[2\] u_mem._0243_ VGND VGND VPWR VPWR u_mem._0309_ sky130_fd_sc_hd__and2b_1
XFILLER_0_18_41 VGND VGND VPWR VPWR sky130_fd_sc_hd__decap_4
Xu_mem._0595_ u_mem.mem\[2\]\[4\] u_mem._0147_ u_mem._0196_ VGND VGND VPWR VPWR u_mem._0201_
+ sky130_fd_sc_hd__mux2_1
XFILLER_0_19_7 VGND VGND VPWR VPWR sky130_fd_sc_hd__decap_6
Xu_mem._1078_ wr_clk u_mem._0106_ VGND VGND VPWR VPWR u_mem.mem\[10\]\[2\] sky130_fd_sc_hd__dfxtp_1
XFILLER_0_11_262 VGND VGND VPWR VPWR sky130_fd_sc_hd__decap_4
XFILLER_0_29_159 VGND VGND VPWR VPWR sky130_fd_sc_hd__fill_1
XFILLER_0_37_181 VGND VGND VPWR VPWR sky130_fd_sc_hd__fill_2
XFILLER_0_4_226 VPWR VGND VPWR VGND sky130_ef_sc_hd__decap_12
Xu_mem._1001_ wr_clk u_mem._0029_ VGND VGND VPWR VPWR u_mem.mem\[8\]\[5\] sky130_fd_sc_hd__dfxtp_1
XFILLER_0_29_73 VGND VGND VPWR VPWR sky130_fd_sc_hd__decap_6
Xu_mem._0716_ u_mem._0269_ u_mem._0292_ u_mem._0254_ VGND VGND VPWR VPWR u_mem._0293_
+ sky130_fd_sc_hd__a21oi_1
Xu_mem._0647_ u_mem._0228_ VGND VGND VPWR VPWR u_mem._0068_ sky130_fd_sc_hd__clkbuf_1
Xu_mem._0578_ u_mem._0191_ VGND VGND VPWR VPWR u_mem._0036_ sky130_fd_sc_hd__clkbuf_1
XFILLER_0_0_41 VPWR VGND VPWR VGND sky130_ef_sc_hd__decap_12
XFILLER_0_0_85 VPWR VGND VPWR VGND sky130_ef_sc_hd__decap_12
XFILLER_0_34_195 VGND VGND VPWR VPWR sky130_fd_sc_hd__fill_1
Xu_mem._0501_ net5 VGND VGND VPWR VPWR u_mem._0147_ sky130_fd_sc_hd__buf_2
XFILLER_0_17_129 VGND VGND VPWR VPWR sky130_fd_sc_hd__fill_1
XFILLER_0_40_187 VGND VGND VPWR VPWR sky130_fd_sc_hd__decap_8
XFILLER_0_40_165 VPWR VGND VPWR VGND sky130_ef_sc_hd__decap_12
XFILLER_0_40_132 VGND VGND VPWR VPWR sky130_fd_sc_hd__decap_8
XFILLER_0_25_173 VGND VGND VPWR VPWR sky130_fd_sc_hd__fill_1
XFILLER_0_31_187 VGND VGND VPWR VPWR sky130_fd_sc_hd__decap_4
Xu_mem._0981_ wr_clk u_mem._0009_ VGND VGND VPWR VPWR u_mem.mem\[4\]\[1\] sky130_fd_sc_hd__dfxtp_1
XFILLER_0_26_85 VPWR VGND VPWR VGND sky130_ef_sc_hd__decap_12
XFILLER_0_42_73 VGND VGND VPWR VPWR sky130_fd_sc_hd__decap_4
XFILLER_0_42_62 VGND VGND VPWR VPWR sky130_fd_sc_hd__decap_3
XFILLER_0_13_154 VGND VGND VPWR VPWR sky130_fd_sc_hd__fill_1
XPHY_88 VGND VGND VPWR VPWR sky130_fd_sc_hd__decap_3
XPHY_77 VGND VGND VPWR VPWR sky130_fd_sc_hd__decap_3
XPHY_11 VGND VGND VPWR VPWR sky130_fd_sc_hd__decap_3
XPHY_22 VGND VGND VPWR VPWR sky130_fd_sc_hd__decap_3
XPHY_33 VGND VGND VPWR VPWR sky130_fd_sc_hd__decap_3
XPHY_44 VGND VGND VPWR VPWR sky130_fd_sc_hd__decap_3
XPHY_55 VGND VGND VPWR VPWR sky130_fd_sc_hd__decap_3
XPHY_66 VGND VGND VPWR VPWR sky130_fd_sc_hd__decap_3
Xu_write._86_ wr_clk u_write._03_ VGND VGND VPWR VPWR u_sync_wr2rd.gray_in\[3\] sky130_fd_sc_hd__dfxtp_1
XFILLER_0_27_246 VPWR VGND VPWR VGND sky130_ef_sc_hd__decap_12
Xu_mem._0964_ u_mem.mem\[9\]\[4\] net5 u_mem._0477_ VGND VGND VPWR VPWR u_mem._0482_
+ sky130_fd_sc_hd__mux2_1
XFILLER_0_37_40 VPWR VGND VPWR VGND sky130_ef_sc_hd__decap_12
Xu_mem._0895_ u_mem._0445_ VGND VGND VPWR VPWR u_mem._0099_ sky130_fd_sc_hd__clkbuf_1
XFILLER_0_18_235 VPWR VGND VPWR VGND sky130_ef_sc_hd__decap_12
Xu_read._60_ u_mem.rd_addr\[1\] u_mem.rd_addr\[0\] u_mem.rd_addr\[2\] VGND VGND VPWR
+ VPWR u_read._24_ sky130_fd_sc_hd__or3b_1
XFILLER_0_33_249 VGND VGND VPWR VPWR sky130_fd_sc_hd__decap_8
XTAP_190 VGND VPWR sky130_fd_sc_hd__tapvpwrvgnd_1
Xu_write._69_ u_write._17_ u_write._30_ u_write._33_ net10 VGND VGND VPWR VPWR u_write._02_
+ sky130_fd_sc_hd__a211oi_1
Xu_mem._0680_ u_mem.rd_addr\[0\] VGND VGND VPWR VPWR u_mem._0258_ sky130_fd_sc_hd__buf_4
Xu_mem._1094_ wr_clk u_mem._0122_ VGND VGND VPWR VPWR u_mem.mem\[5\]\[2\] sky130_fd_sc_hd__dfxtp_1
Xu_mem._0878_ u_mem._0436_ VGND VGND VPWR VPWR u_mem._0091_ sky130_fd_sc_hd__clkbuf_1
Xu_mem._0947_ u_mem.mem\[5\]\[4\] net5 u_mem._0468_ VGND VGND VPWR VPWR u_mem._0473_
+ sky130_fd_sc_hd__mux2_1
Xu_read._43_ u_read.rd_ptr_gray\[3\] u_read.wr_gray_sync2\[3\] VGND VGND VPWR VPWR
+ u_read._09_ sky130_fd_sc_hd__xor2_1
Xu_mem._0732_ u_mem._0241_ u_mem.mem\[4\]\[2\] VGND VGND VPWR VPWR u_mem._0308_ sky130_fd_sc_hd__nor2_1
Xu_mem._0801_ u_mem.mem\[0\]\[5\] u_mem.mem\[1\]\[5\] u_mem._0266_ VGND VGND VPWR
+ VPWR u_mem._0374_ sky130_fd_sc_hd__mux2_1
Xu_mem._0594_ u_mem._0200_ VGND VGND VPWR VPWR u_mem._0043_ sky130_fd_sc_hd__clkbuf_1
Xu_mem._0663_ u_mem.rd_addr\[0\] VGND VGND VPWR VPWR u_mem._0241_ sky130_fd_sc_hd__clkbuf_4
XFILLER_0_7_257 VPWR VGND VPWR VGND sky130_ef_sc_hd__decap_12
XFILLER_0_34_85 VGND VGND VPWR VPWR sky130_fd_sc_hd__decap_4
Xu_mem._1077_ wr_clk u_mem._0105_ VGND VGND VPWR VPWR u_mem.mem\[10\]\[1\] sky130_fd_sc_hd__dfxtp_1
Xu_sync_wr2rd._49_ rd_clk u_sync_wr2rd._09_ VGND VGND VPWR VPWR u_sync_wr2rd.gray_sync1\[4\]
+ sky130_fd_sc_hd__dfxtp_1
XFILLER_0_39_19 VGND VGND VPWR VPWR sky130_fd_sc_hd__decap_8
XFILLER_0_37_160 VGND VGND VPWR VPWR sky130_fd_sc_hd__fill_1
Xu_mem._1000_ wr_clk u_mem._0028_ VGND VGND VPWR VPWR u_mem.mem\[8\]\[4\] sky130_fd_sc_hd__dfxtp_1
XFILLER_0_4_238 VPWR VGND VPWR VGND sky130_ef_sc_hd__decap_12
Xu_mem._0715_ u_mem.mem\[2\]\[1\] u_mem.mem\[3\]\[1\] u_mem._0270_ VGND VGND VPWR
+ VPWR u_mem._0292_ sky130_fd_sc_hd__mux2_1
XFILLER_0_29_52 VGND VGND VPWR VPWR sky130_fd_sc_hd__decap_4
Xu_mem._0646_ u_mem.mem\[11\]\[4\] net5 u_mem._0223_ VGND VGND VPWR VPWR u_mem._0228_
+ sky130_fd_sc_hd__mux2_1
Xu_mem._0577_ u_mem._0147_ u_mem.mem\[13\]\[4\] u_mem._0186_ VGND VGND VPWR VPWR u_mem._0191_
+ sky130_fd_sc_hd__mux2_1
XFILLER_0_0_53 VGND VGND VPWR VPWR sky130_fd_sc_hd__decap_3
XFILLER_0_0_97 VPWR VGND VPWR VGND sky130_ef_sc_hd__decap_12
XFILLER_0_19_160 VGND VGND VPWR VPWR sky130_fd_sc_hd__decap_3
XFILLER_0_34_141 VGND VGND VPWR VPWR sky130_fd_sc_hd__decap_8
Xu_mem._0500_ u_mem._0146_ VGND VGND VPWR VPWR u_mem._0003_ sky130_fd_sc_hd__clkbuf_1
XFILLER_0_40_177 VGND VGND VPWR VPWR sky130_fd_sc_hd__decap_4
XFILLER_0_22_3 VGND VGND VPWR VPWR sky130_fd_sc_hd__decap_8
Xu_mem._0629_ u_mem.mem\[6\]\[4\] u_mem._0147_ u_mem._0214_ VGND VGND VPWR VPWR u_mem._0219_
+ sky130_fd_sc_hd__mux2_1
XFILLER_0_16_130 VGND VGND VPWR VPWR sky130_fd_sc_hd__decap_3
XFILLER_0_16_141 VPWR VGND VPWR VGND sky130_ef_sc_hd__decap_12
XFILLER_0_31_166 VGND VGND VPWR VPWR sky130_fd_sc_hd__fill_2
XFILLER_0_39_200 VPWR VGND VPWR VGND sky130_ef_sc_hd__decap_12
Xu_mem._0980_ wr_clk u_mem._0008_ VGND VGND VPWR VPWR u_mem.mem\[4\]\[0\] sky130_fd_sc_hd__dfxtp_1
XFILLER_0_22_100 VPWR VGND VPWR VGND sky130_ef_sc_hd__decap_12
XFILLER_0_9_105 VGND VGND VPWR VPWR sky130_fd_sc_hd__decap_6
XFILLER_0_26_53 VGND VGND VPWR VPWR sky130_fd_sc_hd__decap_8
XFILLER_0_26_97 VGND VGND VPWR VPWR sky130_fd_sc_hd__decap_3
XFILLER_0_45_225 VPWR VGND VPWR VGND sky130_ef_sc_hd__decap_12
XFILLER_0_13_111 VGND VGND VPWR VPWR sky130_fd_sc_hd__fill_1
XFILLER_0_6_85 VGND VGND VPWR VPWR sky130_fd_sc_hd__fill_1
XPHY_12 VGND VGND VPWR VPWR sky130_fd_sc_hd__decap_3
XPHY_89 VGND VGND VPWR VPWR sky130_fd_sc_hd__decap_3
XPHY_78 VGND VGND VPWR VPWR sky130_fd_sc_hd__decap_3
XPHY_67 VGND VGND VPWR VPWR sky130_fd_sc_hd__decap_3
XPHY_23 VGND VGND VPWR VPWR sky130_fd_sc_hd__decap_3
XPHY_34 VGND VGND VPWR VPWR sky130_fd_sc_hd__decap_3
XPHY_45 VGND VGND VPWR VPWR sky130_fd_sc_hd__decap_3
XPHY_56 VGND VGND VPWR VPWR sky130_fd_sc_hd__decap_3
Xu_write._85_ wr_clk u_write._02_ VGND VGND VPWR VPWR u_sync_wr2rd.gray_in\[2\] sky130_fd_sc_hd__dfxtp_1
XFILLER_0_27_258 VPWR VGND VPWR VGND sky130_ef_sc_hd__decap_12
Xu_mem._0894_ u_mem._0145_ u_mem.mem\[15\]\[3\] u_mem._0441_ VGND VGND VPWR VPWR u_mem._0445_
+ sky130_fd_sc_hd__mux2_1
Xu_mem._0963_ u_mem._0481_ VGND VGND VPWR VPWR u_mem._0131_ sky130_fd_sc_hd__clkbuf_1
XFILLER_0_37_52 VGND VGND VPWR VPWR sky130_fd_sc_hd__decap_4
XFILLER_0_18_247 VGND VGND VPWR VPWR sky130_fd_sc_hd__decap_4
XFILLER_0_18_269 VGND VGND VPWR VPWR sky130_fd_sc_hd__fill_1
XFILLER_0_41_261 VGND VGND VPWR VPWR sky130_fd_sc_hd__decap_6
XFILLER_0_5_174 VGND VGND VPWR VPWR sky130_fd_sc_hd__decap_6
XTAP_180 VGND VPWR sky130_fd_sc_hd__tapvpwrvgnd_1
XTAP_191 VGND VPWR sky130_fd_sc_hd__tapvpwrvgnd_1
Xu_write._68_ u_sync_wr2rd.gray_in\[2\] u_write._29_ VGND VGND VPWR VPWR u_write._33_
+ sky130_fd_sc_hd__nor2_1
XFILLER_0_23_54 VGND VGND VPWR VPWR sky130_fd_sc_hd__fill_2
Xu_mem._1093_ wr_clk u_mem._0121_ VGND VGND VPWR VPWR u_mem.mem\[5\]\[1\] sky130_fd_sc_hd__dfxtp_1
XFILLER_0_23_261 VGND VGND VPWR VPWR sky130_fd_sc_hd__decap_8
Xu_mem._0877_ u_mem._0145_ u_mem.mem\[14\]\[3\] u_mem._0432_ VGND VGND VPWR VPWR u_mem._0436_
+ sky130_fd_sc_hd__mux2_1
Xu_mem._0946_ u_mem._0472_ VGND VGND VPWR VPWR u_mem._0123_ sky130_fd_sc_hd__clkbuf_1
Xu_mem._0731_ u_mem._0236_ u_mem._0306_ VGND VGND VPWR VPWR u_mem._0307_ sky130_fd_sc_hd__nand2_1
Xu_mem._0800_ u_mem._0240_ u_mem._0371_ u_mem._0372_ u_mem._0245_ VGND VGND VPWR VPWR
+ u_mem._0373_ sky130_fd_sc_hd__o31a_1
Xu_mem._0593_ u_mem.mem\[2\]\[3\] u_mem._0145_ u_mem._0196_ VGND VGND VPWR VPWR u_mem._0200_
+ sky130_fd_sc_hd__mux2_1
Xu_mem._0662_ u_mem._0235_ VGND VGND VPWR VPWR u_mem._0240_ sky130_fd_sc_hd__clkbuf_4
Xu_mem._1076_ wr_clk u_mem._0104_ VGND VGND VPWR VPWR u_mem.mem\[10\]\[0\] sky130_fd_sc_hd__dfxtp_1
XFILLER_0_7_269 VGND VGND VPWR VPWR sky130_fd_sc_hd__fill_1
Xu_mem._0929_ u_mem._0463_ VGND VGND VPWR VPWR u_mem._0115_ sky130_fd_sc_hd__clkbuf_1
XFILLER_0_38_139 VGND VGND VPWR VPWR sky130_fd_sc_hd__fill_1
XFILLER_0_38_106 VGND VGND VPWR VPWR sky130_fd_sc_hd__decap_3
Xu_sync_wr2rd._48_ rd_clk u_sync_wr2rd._08_ VGND VGND VPWR VPWR u_sync_wr2rd.gray_sync1\[3\]
+ sky130_fd_sc_hd__dfxtp_1
XFILLER_0_20_66 VGND VGND VPWR VPWR sky130_fd_sc_hd__fill_2
Xu_mem._0714_ u_mem._0265_ u_mem._0290_ VGND VGND VPWR VPWR u_mem._0291_ sky130_fd_sc_hd__or2b_1
Xu_mem._0645_ u_mem._0227_ VGND VGND VPWR VPWR u_mem._0067_ sky130_fd_sc_hd__clkbuf_1
XFILLER_0_45_85 VPWR VGND VPWR VGND sky130_ef_sc_hd__decap_12
XFILLER_0_45_41 VPWR VGND VPWR VGND sky130_ef_sc_hd__decap_12
Xu_mem._0576_ u_mem._0190_ VGND VGND VPWR VPWR u_mem._0035_ sky130_fd_sc_hd__clkbuf_1
Xu_mem._1059_ wr_clk u_mem._0087_ VGND VGND VPWR VPWR u_mem.mem\[1\]\[7\] sky130_fd_sc_hd__dfxtp_1
XFILLER_0_26_109 VGND VGND VPWR VPWR sky130_fd_sc_hd__fill_2
XFILLER_0_34_197 VPWR VGND VPWR VGND sky130_ef_sc_hd__decap_12
XFILLER_0_15_11 VGND VGND VPWR VPWR sky130_fd_sc_hd__fill_2
XFILLER_0_15_22 VGND VGND VPWR VPWR sky130_fd_sc_hd__fill_2
XFILLER_0_15_55 VGND VGND VPWR VPWR sky130_fd_sc_hd__fill_1
XFILLER_0_0_253 VPWR VGND VPWR VGND sky130_ef_sc_hd__decap_12
XFILLER_0_15_3 VGND VGND VPWR VPWR sky130_fd_sc_hd__decap_8
Xu_mem._0628_ u_mem._0218_ VGND VGND VPWR VPWR u_mem._0059_ sky130_fd_sc_hd__clkbuf_1
Xu_mem._0559_ u_mem._0181_ VGND VGND VPWR VPWR u_mem._0027_ sky130_fd_sc_hd__clkbuf_1
XFILLER_0_16_153 VGND VGND VPWR VPWR sky130_fd_sc_hd__decap_6
XFILLER_0_39_212 VPWR VGND VPWR VGND sky130_ef_sc_hd__decap_12
XFILLER_0_22_178 VPWR VGND VPWR VGND sky130_ef_sc_hd__decap_12
XFILLER_0_45_237 VPWR VGND VPWR VGND sky130_ef_sc_hd__decap_12
XFILLER_0_13_167 VGND VGND VPWR VPWR sky130_fd_sc_hd__fill_1
XPHY_13 VGND VGND VPWR VPWR sky130_fd_sc_hd__decap_3
XPHY_24 VGND VGND VPWR VPWR sky130_fd_sc_hd__decap_3
XPHY_35 VGND VGND VPWR VPWR sky130_fd_sc_hd__decap_3
XPHY_46 VGND VGND VPWR VPWR sky130_fd_sc_hd__decap_3
XPHY_79 VGND VGND VPWR VPWR sky130_fd_sc_hd__decap_3
XFILLER_0_36_237 VGND VGND VPWR VPWR sky130_fd_sc_hd__fill_2
XFILLER_0_8_150 VGND VGND VPWR VPWR sky130_fd_sc_hd__decap_8
XPHY_57 VGND VGND VPWR VPWR sky130_fd_sc_hd__decap_3
XPHY_68 VGND VGND VPWR VPWR sky130_fd_sc_hd__decap_3
Xu_write._84_ wr_clk u_write._01_ VGND VGND VPWR VPWR u_sync_wr2rd.gray_in\[1\] sky130_fd_sc_hd__dfxtp_1
XFILLER_0_4_3 VPWR VGND VPWR VGND sky130_ef_sc_hd__decap_12
XFILLER_0_12_23 VGND VGND VPWR VPWR sky130_fd_sc_hd__fill_2
XFILLER_0_12_45 VGND VGND VPWR VPWR sky130_fd_sc_hd__fill_2
Xu_mem._0893_ u_mem._0444_ VGND VGND VPWR VPWR u_mem._0098_ sky130_fd_sc_hd__clkbuf_1
Xu_mem._0962_ u_mem.mem\[9\]\[3\] net4 u_mem._0477_ VGND VGND VPWR VPWR u_mem._0481_
+ sky130_fd_sc_hd__mux2_1
XFILLER_0_18_215 VGND VGND VPWR VPWR sky130_fd_sc_hd__decap_8
XTAP_170 VGND VPWR sky130_fd_sc_hd__tapvpwrvgnd_1
XTAP_181 VGND VPWR sky130_fd_sc_hd__tapvpwrvgnd_1
XTAP_192 VGND VPWR sky130_fd_sc_hd__tapvpwrvgnd_1
Xu_write._67_ u_write._21_ u_write._22_ u_write._30_ u_write._32_ net10 VGND VGND
+ VPWR VPWR u_write._01_ sky130_fd_sc_hd__a311oi_1
Xu_mem._1092_ wr_clk u_mem._0120_ VGND VGND VPWR VPWR u_mem.mem\[5\]\[0\] sky130_fd_sc_hd__dfxtp_1
XFILLER_0_23_11 VGND VGND VPWR VPWR sky130_fd_sc_hd__fill_2
XFILLER_0_23_22 VPWR VGND VPWR VGND sky130_ef_sc_hd__decap_12
XFILLER_0_2_101 VGND VGND VPWR VPWR sky130_fd_sc_hd__decap_3
Xu_mem._0876_ u_mem._0435_ VGND VGND VPWR VPWR u_mem._0090_ sky130_fd_sc_hd__clkbuf_1
Xu_mem._0945_ u_mem.mem\[5\]\[3\] net4 u_mem._0468_ VGND VGND VPWR VPWR u_mem._0472_
+ sky130_fd_sc_hd__mux2_1
XFILLER_0_14_251 VGND VGND VPWR VPWR sky130_fd_sc_hd__fill_1
Xu_mem._0661_ u_mem._0236_ u_mem._0238_ VGND VGND VPWR VPWR u_mem._0239_ sky130_fd_sc_hd__nand2_1
Xu_mem._0730_ u_mem.mem\[6\]\[2\] u_mem.mem\[7\]\[2\] u_mem._0258_ VGND VGND VPWR
+ VPWR u_mem._0306_ sky130_fd_sc_hd__mux2_1
XFILLER_0_18_22 VGND VGND VPWR VPWR sky130_fd_sc_hd__decap_6
XFILLER_0_18_66 VGND VGND VPWR VPWR sky130_fd_sc_hd__decap_8
XFILLER_0_18_77 VGND VGND VPWR VPWR sky130_fd_sc_hd__decap_6
Xu_mem._0592_ u_mem._0199_ VGND VGND VPWR VPWR u_mem._0042_ sky130_fd_sc_hd__clkbuf_1
Xu_mem._1075_ wr_clk u_mem._0103_ VGND VGND VPWR VPWR u_mem.mem\[15\]\[7\] sky130_fd_sc_hd__dfxtp_1
Xu_mem._0928_ u_mem.mem\[0\]\[3\] net4 u_mem._0459_ VGND VGND VPWR VPWR u_mem._0463_
+ sky130_fd_sc_hd__mux2_1
Xu_mem._0859_ u_mem._0426_ VGND VGND VPWR VPWR u_mem._0082_ sky130_fd_sc_hd__clkbuf_1
Xu_sync_wr2rd._47_ rd_clk u_sync_wr2rd._07_ VGND VGND VPWR VPWR u_sync_wr2rd.gray_sync1\[2\]
+ sky130_fd_sc_hd__dfxtp_1
XFILLER_0_45_53 VGND VGND VPWR VPWR sky130_fd_sc_hd__decap_3
Xu_mem._0575_ u_mem._0145_ u_mem.mem\[13\]\[3\] u_mem._0186_ VGND VGND VPWR VPWR u_mem._0190_
+ sky130_fd_sc_hd__mux2_1
Xu_mem._0713_ u_mem.mem\[0\]\[1\] u_mem.mem\[1\]\[1\] u_mem._0266_ VGND VGND VPWR
+ VPWR u_mem._0290_ sky130_fd_sc_hd__mux2_1
Xu_mem._0644_ u_mem.mem\[11\]\[3\] net4 u_mem._0223_ VGND VGND VPWR VPWR u_mem._0227_
+ sky130_fd_sc_hd__mux2_1
XFILLER_0_31_9 VGND VGND VPWR VPWR sky130_fd_sc_hd__fill_1
XFILLER_0_45_97 VPWR VGND VPWR VGND sky130_ef_sc_hd__decap_12
Xu_mem._1058_ wr_clk u_mem._0086_ VGND VGND VPWR VPWR u_mem.mem\[1\]\[6\] sky130_fd_sc_hd__dfxtp_1
XFILLER_0_25_110 VGND VGND VPWR VPWR sky130_fd_sc_hd__fill_2
XFILLER_0_31_55 VGND VGND VPWR VPWR sky130_fd_sc_hd__fill_1
XFILLER_0_0_221 VGND VGND VPWR VPWR sky130_fd_sc_hd__decap_3
XFILLER_0_0_265 VGND VGND VPWR VPWR sky130_fd_sc_hd__decap_4
Xu_mem._0558_ u_mem.mem\[8\]\[3\] u_mem._0145_ u_mem._0177_ VGND VGND VPWR VPWR u_mem._0181_
+ sky130_fd_sc_hd__mux2_1
Xu_mem._0627_ u_mem.mem\[6\]\[3\] u_mem._0145_ u_mem._0214_ VGND VGND VPWR VPWR u_mem._0218_
+ sky130_fd_sc_hd__mux2_1
Xu_mem._0489_ u_mem._0137_ u_mem._0138_ VGND VGND VPWR VPWR u_mem._0139_ sky130_fd_sc_hd__nor2_4
XFILLER_0_6_7 VPWR VGND VPWR VGND sky130_ef_sc_hd__decap_12
XFILLER_0_39_246 VPWR VGND VPWR VGND sky130_ef_sc_hd__decap_12
XFILLER_0_22_157 VGND VGND VPWR VPWR sky130_fd_sc_hd__decap_4
XFILLER_0_45_249 VGND VGND VPWR VPWR sky130_fd_sc_hd__decap_3
XFILLER_0_13_113 VGND VGND VPWR VPWR sky130_fd_sc_hd__fill_1
XFILLER_0_6_98 VPWR VGND VPWR VGND sky130_ef_sc_hd__decap_12
XPHY_69 VGND VGND VPWR VPWR sky130_fd_sc_hd__decap_3
XPHY_14 VGND VGND VPWR VPWR sky130_fd_sc_hd__decap_3
XPHY_25 VGND VGND VPWR VPWR sky130_fd_sc_hd__decap_3
XPHY_36 VGND VGND VPWR VPWR sky130_fd_sc_hd__decap_3
XPHY_47 VGND VGND VPWR VPWR sky130_fd_sc_hd__decap_3
XPHY_58 VGND VGND VPWR VPWR sky130_fd_sc_hd__decap_3
XFILLER_0_36_205 VGND VGND VPWR VPWR sky130_fd_sc_hd__decap_3
Xu_write._83_ wr_clk u_write._00_ VGND VGND VPWR VPWR u_sync_wr2rd.gray_in\[0\] sky130_fd_sc_hd__dfxtp_1
Xu_mem._0961_ u_mem._0480_ VGND VGND VPWR VPWR u_mem._0130_ sky130_fd_sc_hd__clkbuf_1
Xu_mem._0892_ u_mem._0143_ u_mem.mem\[15\]\[2\] u_mem._0441_ VGND VGND VPWR VPWR u_mem._0444_
+ sky130_fd_sc_hd__mux2_1
XFILLER_0_10_127 VGND VGND VPWR VPWR sky130_fd_sc_hd__decap_3
XFILLER_0_33_219 VGND VGND VPWR VPWR sky130_fd_sc_hd__fill_1
XFILLER_0_18_205 VGND VGND VPWR VPWR sky130_fd_sc_hd__fill_1
XFILLER_0_5_165 VGND VGND VPWR VPWR sky130_fd_sc_hd__decap_3
XTAP_160 VGND VPWR sky130_fd_sc_hd__tapvpwrvgnd_1
XTAP_171 VGND VPWR sky130_fd_sc_hd__tapvpwrvgnd_1
XTAP_182 VGND VPWR sky130_fd_sc_hd__tapvpwrvgnd_1
XTAP_193 VGND VPWR sky130_fd_sc_hd__tapvpwrvgnd_1
Xu_write._66_ u_sync_wr2rd.gray_in\[1\] u_write._29_ VGND VGND VPWR VPWR u_write._32_
+ sky130_fd_sc_hd__nor2_1
Xu_mem._1091_ wr_clk u_mem._0119_ VGND VGND VPWR VPWR u_mem.mem\[0\]\[7\] sky130_fd_sc_hd__dfxtp_1
XFILLER_0_23_34 VPWR VGND VPWR VGND sky130_ef_sc_hd__decap_12
XFILLER_0_2_157 VGND VGND VPWR VPWR sky130_fd_sc_hd__fill_1
Xu_mem._0944_ u_mem._0471_ VGND VGND VPWR VPWR u_mem._0122_ sky130_fd_sc_hd__clkbuf_1
Xu_mem._0875_ u_mem._0143_ u_mem.mem\[14\]\[2\] u_mem._0432_ VGND VGND VPWR VPWR u_mem._0435_
+ sky130_fd_sc_hd__mux2_1
XFILLER_0_3_55 VGND VGND VPWR VPWR sky130_fd_sc_hd__fill_1
Xu_write._49_ u_mem.wr_addr\[3\] u_write._10_ u_write._16_ VGND VGND VPWR VPWR u_write._17_
+ sky130_fd_sc_hd__mux2_1
Xu_mem._0591_ u_mem.mem\[2\]\[2\] u_mem._0143_ u_mem._0196_ VGND VGND VPWR VPWR u_mem._0199_
+ sky130_fd_sc_hd__mux2_1
Xu_mem._0660_ u_mem.mem\[14\]\[0\] u_mem.mem\[15\]\[0\] u_mem._0237_ VGND VGND VPWR
+ VPWR u_mem._0238_ sky130_fd_sc_hd__mux2_1
Xu_mem._1074_ wr_clk u_mem._0102_ VGND VGND VPWR VPWR u_mem.mem\[15\]\[6\] sky130_fd_sc_hd__dfxtp_1
Xu_mem._0927_ u_mem._0462_ VGND VGND VPWR VPWR u_mem._0114_ sky130_fd_sc_hd__clkbuf_1
XFILLER_0_11_266 VGND VGND VPWR VPWR sky130_fd_sc_hd__fill_1
XFILLER_0_38_3 VPWR VGND VPWR VGND sky130_ef_sc_hd__decap_12
Xu_mem._0858_ u_mem.mem\[1\]\[2\] net3 u_mem._0423_ VGND VGND VPWR VPWR u_mem._0426_
+ sky130_fd_sc_hd__mux2_1
Xu_mem._0789_ u_mem.mem\[13\]\[5\] u_mem._0266_ VGND VGND VPWR VPWR u_mem._0362_ sky130_fd_sc_hd__and2b_1
Xu_sync_wr2rd._46_ rd_clk u_sync_wr2rd._06_ VGND VGND VPWR VPWR u_sync_wr2rd.gray_sync1\[1\]
+ sky130_fd_sc_hd__dfxtp_1
XFILLER_0_20_24 VGND VGND VPWR VPWR sky130_fd_sc_hd__decap_4
Xu_mem._0712_ u_mem._0247_ u_mem._0287_ u_mem._0288_ u_mem._0263_ VGND VGND VPWR VPWR
+ u_mem._0289_ sky130_fd_sc_hd__o31a_1
Xu_mem._0574_ u_mem._0189_ VGND VGND VPWR VPWR u_mem._0034_ sky130_fd_sc_hd__clkbuf_1
Xu_mem._0643_ u_mem._0226_ VGND VGND VPWR VPWR u_mem._0066_ sky130_fd_sc_hd__clkbuf_1
XFILLER_0_9_43 VGND VGND VPWR VPWR sky130_fd_sc_hd__decap_6
Xu_mem._1057_ wr_clk u_mem._0085_ VGND VGND VPWR VPWR u_mem.mem\[1\]\[5\] sky130_fd_sc_hd__dfxtp_1
XFILLER_0_19_185 VPWR VGND VPWR VGND sky130_ef_sc_hd__decap_12
Xu_sync_wr2rd._29_ u_sync_wr2rd._14_ VGND VGND VPWR VPWR u_sync_wr2rd._04_ sky130_fd_sc_hd__clkbuf_1
XFILLER_0_15_57 VPWR VGND VPWR VGND sky130_ef_sc_hd__decap_12
Xu_mem._0557_ u_mem._0180_ VGND VGND VPWR VPWR u_mem._0026_ sky130_fd_sc_hd__clkbuf_1
Xu_mem._0626_ u_mem._0217_ VGND VGND VPWR VPWR u_mem._0058_ sky130_fd_sc_hd__clkbuf_1
Xu_mem._0488_ u_mem.wr_addr\[0\] u_mem.wr_addr\[1\] VGND VGND VPWR VPWR u_mem._0138_
+ sky130_fd_sc_hd__nand2_4
XFILLER_0_16_111 VGND VGND VPWR VPWR sky130_fd_sc_hd__decap_8
XFILLER_0_16_122 VGND VGND VPWR VPWR sky130_fd_sc_hd__decap_8
XFILLER_0_31_136 VPWR VGND VPWR VGND sky130_ef_sc_hd__decap_12
XFILLER_0_31_169 VGND VGND VPWR VPWR sky130_fd_sc_hd__fill_2
XFILLER_0_39_258 VPWR VGND VPWR VGND sky130_ef_sc_hd__decap_12
XFILLER_0_39_225 VPWR VGND VPWR VGND sky130_ef_sc_hd__decap_12
XFILLER_0_42_55 VGND VGND VPWR VPWR sky130_fd_sc_hd__fill_1
XFILLER_0_20_3 VGND VGND VPWR VPWR sky130_fd_sc_hd__decap_4
XPHY_15 VGND VGND VPWR VPWR sky130_fd_sc_hd__decap_3
Xu_mem._0609_ u_mem._0208_ VGND VGND VPWR VPWR u_mem._0050_ sky130_fd_sc_hd__clkbuf_1
XPHY_26 VGND VGND VPWR VPWR sky130_fd_sc_hd__decap_3
XPHY_37 VGND VGND VPWR VPWR sky130_fd_sc_hd__decap_3
XPHY_48 VGND VGND VPWR VPWR sky130_fd_sc_hd__decap_3
XPHY_59 VGND VGND VPWR VPWR sky130_fd_sc_hd__decap_3
Xu_write._82_ u_write._10_ u_write._30_ u_write._40_ net10 VGND VGND VPWR VPWR u_write._08_
+ sky130_fd_sc_hd__a211oi_1
Xu_mem._0891_ u_mem._0443_ VGND VGND VPWR VPWR u_mem._0097_ sky130_fd_sc_hd__clkbuf_1
Xu_mem._0960_ u_mem.mem\[9\]\[2\] net3 u_mem._0477_ VGND VGND VPWR VPWR u_mem._0480_
+ sky130_fd_sc_hd__mux2_1
XFILLER_0_41_231 VGND VGND VPWR VPWR sky130_fd_sc_hd__fill_1
XFILLER_0_5_111 VGND VGND VPWR VPWR sky130_fd_sc_hd__fill_1
XTAP_150 VGND VPWR sky130_fd_sc_hd__tapvpwrvgnd_1
XTAP_161 VGND VPWR sky130_fd_sc_hd__tapvpwrvgnd_1
XTAP_172 VGND VPWR sky130_fd_sc_hd__tapvpwrvgnd_1
XTAP_183 VGND VPWR sky130_fd_sc_hd__tapvpwrvgnd_1
XTAP_194 VGND VPWR sky130_fd_sc_hd__tapvpwrvgnd_1
Xu_write._65_ u_mem.wr_addr\[1\] u_write._30_ u_write._31_ net10 VGND VGND VPWR VPWR
+ u_write._00_ sky130_fd_sc_hd__a211oi_1
XFILLER_0_17_261 VGND VGND VPWR VPWR sky130_fd_sc_hd__decap_8
XFILLER_0_32_253 VPWR VGND VPWR VGND sky130_ef_sc_hd__decap_12
XFILLER_0_23_46 VGND VGND VPWR VPWR sky130_fd_sc_hd__decap_8
Xu_mem._1090_ wr_clk u_mem._0118_ VGND VGND VPWR VPWR u_mem.mem\[0\]\[6\] sky130_fd_sc_hd__dfxtp_1
Xu_mem._0874_ u_mem._0434_ VGND VGND VPWR VPWR u_mem._0089_ sky130_fd_sc_hd__clkbuf_1
Xu_mem._0943_ u_mem.mem\[5\]\[2\] net3 u_mem._0468_ VGND VGND VPWR VPWR u_mem._0471_
+ sky130_fd_sc_hd__mux2_1
XFILLER_0_14_253 VPWR VGND VPWR VGND sky130_ef_sc_hd__decap_12
Xu_write._48_ u_write._09_ u_write._15_ VGND VGND VPWR VPWR u_write._16_ sky130_fd_sc_hd__or2_1
XFILLER_0_20_256 VGND VGND VPWR VPWR sky130_fd_sc_hd__decap_3
Xu_mem._0590_ u_mem._0198_ VGND VGND VPWR VPWR u_mem._0041_ sky130_fd_sc_hd__clkbuf_1
XFILLER_0_7_217 VGND VGND VPWR VPWR sky130_fd_sc_hd__fill_2
XFILLER_0_34_45 VGND VGND VPWR VPWR sky130_fd_sc_hd__fill_1
XFILLER_0_34_89 VGND VGND VPWR VPWR sky130_fd_sc_hd__fill_1
XFILLER_0_11_223 VGND VGND VPWR VPWR sky130_fd_sc_hd__fill_1
Xu_mem._1073_ wr_clk u_mem._0101_ VGND VGND VPWR VPWR u_mem.mem\[15\]\[5\] sky130_fd_sc_hd__dfxtp_1
Xu_mem._0926_ u_mem.mem\[0\]\[2\] net3 u_mem._0459_ VGND VGND VPWR VPWR u_mem._0462_
+ sky130_fd_sc_hd__mux2_1
Xu_mem._0857_ u_mem._0425_ VGND VGND VPWR VPWR u_mem._0081_ sky130_fd_sc_hd__clkbuf_1
Xu_mem._0788_ u_mem._0258_ u_mem.mem\[12\]\[5\] VGND VGND VPWR VPWR u_mem._0361_ sky130_fd_sc_hd__nor2_1
Xu_sync_wr2rd._45_ rd_clk u_sync_wr2rd._05_ VGND VGND VPWR VPWR u_sync_wr2rd.gray_sync1\[0\]
+ sky130_fd_sc_hd__dfxtp_1
XFILLER_0_37_164 VGND VGND VPWR VPWR sky130_fd_sc_hd__decap_4
Xu_mem._0711_ u_mem.mem\[5\]\[1\] u_mem._0252_ VGND VGND VPWR VPWR u_mem._0288_ sky130_fd_sc_hd__and2b_1
XFILLER_0_29_45 VGND VGND VPWR VPWR sky130_fd_sc_hd__fill_1
XFILLER_0_45_77 VGND VGND VPWR VPWR sky130_fd_sc_hd__fill_2
Xu_mem._0573_ u_mem._0143_ u_mem.mem\[13\]\[2\] u_mem._0186_ VGND VGND VPWR VPWR u_mem._0189_
+ sky130_fd_sc_hd__mux2_1
Xu_mem._0642_ u_mem.mem\[11\]\[2\] net3 u_mem._0223_ VGND VGND VPWR VPWR u_mem._0226_
+ sky130_fd_sc_hd__mux2_1
XFILLER_0_0_57 VPWR VGND VPWR VGND sky130_ef_sc_hd__decap_12
Xu_mem._1056_ wr_clk u_mem._0084_ VGND VGND VPWR VPWR u_mem.mem\[1\]\[4\] sky130_fd_sc_hd__dfxtp_1
XFILLER_0_3_220 VGND VGND VPWR VPWR sky130_fd_sc_hd__decap_4
XFILLER_0_9_55 VGND VGND VPWR VPWR sky130_fd_sc_hd__fill_1
XFILLER_0_9_66 VPWR VGND VPWR VGND sky130_ef_sc_hd__decap_12
XFILLER_0_10_80 VGND VGND VPWR VPWR sky130_fd_sc_hd__decap_4
Xu_mem._0909_ u_mem.mem\[10\]\[2\] net3 u_mem._0450_ VGND VGND VPWR VPWR u_mem._0453_
+ sky130_fd_sc_hd__mux2_1
Xu_sync_wr2rd._28_ net10 u_sync_wr2rd.gray_sync1\[4\] VGND VGND VPWR VPWR u_sync_wr2rd._14_
+ sky130_fd_sc_hd__and2b_1
XFILLER_0_15_69 VPWR VGND VPWR VGND sky130_ef_sc_hd__decap_12
XFILLER_0_31_35 VPWR VGND VPWR VGND sky130_ef_sc_hd__decap_12
XFILLER_0_31_57 VGND VGND VPWR VPWR sky130_fd_sc_hd__fill_1
XFILLER_0_40_126 VGND VGND VPWR VPWR sky130_fd_sc_hd__decap_3
XFILLER_0_25_167 VGND VGND VPWR VPWR sky130_fd_sc_hd__fill_1
Xu_mem._0625_ u_mem.mem\[6\]\[2\] u_mem._0143_ u_mem._0214_ VGND VGND VPWR VPWR u_mem._0217_
+ sky130_fd_sc_hd__mux2_1
Xu_mem._0487_ u_mem.wr_addr\[2\] u_mem.wr_addr\[3\] net21 net11 VGND VGND VPWR VPWR
+ u_mem._0137_ sky130_fd_sc_hd__or4b_4
Xu_mem._0556_ u_mem.mem\[8\]\[2\] u_mem._0143_ u_mem._0177_ VGND VGND VPWR VPWR u_mem._0180_
+ sky130_fd_sc_hd__mux2_1
Xu_mem._1039_ wr_clk u_mem._0067_ VGND VGND VPWR VPWR u_mem.mem\[11\]\[3\] sky130_fd_sc_hd__dfxtp_1
XFILLER_0_31_148 VGND VGND VPWR VPWR sky130_fd_sc_hd__decap_6
XFILLER_0_39_237 VGND VGND VPWR VPWR sky130_fd_sc_hd__fill_2
XFILLER_0_30_170 VGND VGND VPWR VPWR sky130_fd_sc_hd__decap_4
XFILLER_0_30_192 VGND VGND VPWR VPWR sky130_fd_sc_hd__decap_4
XFILLER_0_6_45 VPWR VGND VPWR VGND sky130_ef_sc_hd__decap_12
Xu_mem._0608_ u_mem.mem\[7\]\[2\] u_mem._0143_ u_mem._0205_ VGND VGND VPWR VPWR u_mem._0208_
+ sky130_fd_sc_hd__mux2_1
XFILLER_0_8_120 VGND VGND VPWR VPWR sky130_fd_sc_hd__fill_1
XPHY_16 VGND VGND VPWR VPWR sky130_fd_sc_hd__decap_3
Xu_mem._0539_ u_mem._0170_ VGND VGND VPWR VPWR u_mem._0018_ sky130_fd_sc_hd__clkbuf_1
XPHY_27 VGND VGND VPWR VPWR sky130_fd_sc_hd__decap_3
XPHY_38 VGND VGND VPWR VPWR sky130_fd_sc_hd__decap_3
XPHY_49 VGND VGND VPWR VPWR sky130_fd_sc_hd__decap_3
XFILLER_0_44_251 VGND VGND VPWR VPWR sky130_fd_sc_hd__fill_1
Xu_write._81_ u_mem.wr_addr\[3\] u_write._29_ VGND VGND VPWR VPWR u_write._40_ sky130_fd_sc_hd__nor2_1
Xu_sync_rd2wr._39_ u_sync_rd2wr._19_ VGND VGND VPWR VPWR u_sync_rd2wr._09_ sky130_fd_sc_hd__clkbuf_1
XFILLER_0_12_181 VGND VGND VPWR VPWR sky130_fd_sc_hd__decap_6
Xu_mem._0890_ u_mem._0141_ u_mem.mem\[15\]\[1\] u_mem._0441_ VGND VGND VPWR VPWR u_mem._0443_
+ sky130_fd_sc_hd__mux2_1
XFILLER_0_37_23 VGND VGND VPWR VPWR sky130_fd_sc_hd__fill_2
XFILLER_0_5_156 VGND VGND VPWR VPWR sky130_fd_sc_hd__decap_6
XTAP_140 VGND VPWR sky130_fd_sc_hd__tapvpwrvgnd_1
XTAP_151 VGND VPWR sky130_fd_sc_hd__tapvpwrvgnd_1
XTAP_162 VGND VPWR sky130_fd_sc_hd__tapvpwrvgnd_1
XTAP_173 VGND VPWR sky130_fd_sc_hd__tapvpwrvgnd_1
XTAP_184 VGND VPWR sky130_fd_sc_hd__tapvpwrvgnd_1
XTAP_195 VGND VPWR sky130_fd_sc_hd__tapvpwrvgnd_1
Xu_write._64_ u_sync_wr2rd.gray_in\[0\] u_write._30_ VGND VGND VPWR VPWR u_write._31_
+ sky130_fd_sc_hd__nor2_1
XFILLER_0_2_3 VPWR VGND VPWR VGND sky130_ef_sc_hd__decap_12
XFILLER_0_32_265 VGND VGND VPWR VPWR sky130_fd_sc_hd__decap_4
Xu_mem._0873_ u_mem._0141_ u_mem.mem\[14\]\[1\] u_mem._0432_ VGND VGND VPWR VPWR u_mem._0434_
+ sky130_fd_sc_hd__mux2_1
Xu_mem._0942_ u_mem._0470_ VGND VGND VPWR VPWR u_mem._0121_ sky130_fd_sc_hd__clkbuf_1
XFILLER_0_3_57 VPWR VGND VPWR VGND sky130_ef_sc_hd__decap_12
XFILLER_0_14_265 VGND VGND VPWR VPWR sky130_fd_sc_hd__decap_4
Xu_write._47_ u_mem.wr_addr\[1\] u_mem.wr_addr\[0\] u_mem.wr_addr\[2\] VGND VGND VPWR
+ VPWR u_write._15_ sky130_fd_sc_hd__a21oi_1
Xu_mem._1072_ wr_clk u_mem._0100_ VGND VGND VPWR VPWR u_mem.mem\[15\]\[4\] sky130_fd_sc_hd__dfxtp_1
Xu_mem._0856_ u_mem.mem\[1\]\[1\] net2 u_mem._0423_ VGND VGND VPWR VPWR u_mem._0425_
+ sky130_fd_sc_hd__mux2_1
Xu_mem._0925_ u_mem._0461_ VGND VGND VPWR VPWR u_mem._0113_ sky130_fd_sc_hd__clkbuf_1
Xu_mem._0787_ u_mem._0269_ u_mem._0359_ VGND VGND VPWR VPWR u_mem._0360_ sky130_fd_sc_hd__nand2_1
XFILLER_0_6_262 VGND VGND VPWR VPWR sky130_fd_sc_hd__decap_4
Xu_sync_wr2rd._44_ rd_clk u_sync_wr2rd._04_ VGND VGND VPWR VPWR u_read.wr_gray_sync2\[4\]
+ sky130_fd_sc_hd__dfxtp_1
XFILLER_0_37_154 VGND VGND VPWR VPWR sky130_fd_sc_hd__decap_6
Xu_mem._0641_ u_mem._0225_ VGND VGND VPWR VPWR u_mem._0065_ sky130_fd_sc_hd__clkbuf_1
Xu_mem._0710_ u_mem._0241_ u_mem.mem\[4\]\[1\] VGND VGND VPWR VPWR u_mem._0287_ sky130_fd_sc_hd__nor2_1
XFILLER_0_29_57 VGND VGND VPWR VPWR sky130_fd_sc_hd__fill_1
XFILLER_0_29_79 VGND VGND VPWR VPWR sky130_fd_sc_hd__fill_1
Xu_mem._0572_ u_mem._0188_ VGND VGND VPWR VPWR u_mem._0033_ sky130_fd_sc_hd__clkbuf_1
XFILLER_0_0_69 VPWR VGND VPWR VGND sky130_ef_sc_hd__decap_12
XFILLER_0_9_78 VGND VGND VPWR VPWR sky130_fd_sc_hd__decap_4
Xu_mem._1055_ wr_clk u_mem._0083_ VGND VGND VPWR VPWR u_mem.mem\[1\]\[3\] sky130_fd_sc_hd__dfxtp_1
Xu_mem._0908_ u_mem._0452_ VGND VGND VPWR VPWR u_mem._0105_ sky130_fd_sc_hd__clkbuf_1
XFILLER_0_43_3 VPWR VGND VPWR VGND sky130_ef_sc_hd__decap_12
Xu_mem._0839_ u_mem._0402_ u_mem._0405_ u_mem._0407_ u_mem._0409_ u_mem._0256_ VGND
+ VGND VPWR VPWR u_mem._0410_ sky130_fd_sc_hd__a221o_1
XFILLER_0_19_132 VGND VGND VPWR VPWR sky130_fd_sc_hd__decap_6
XFILLER_0_34_113 VGND VGND VPWR VPWR sky130_fd_sc_hd__fill_1
Xu_sync_wr2rd._27_ u_sync_wr2rd._13_ VGND VGND VPWR VPWR u_sync_wr2rd._03_ sky130_fd_sc_hd__clkbuf_1
XFILLER_0_25_135 VPWR VGND VPWR VGND sky130_ef_sc_hd__decap_12
XFILLER_0_31_47 VGND VGND VPWR VPWR sky130_fd_sc_hd__decap_8
Xu_mem._0624_ u_mem._0216_ VGND VGND VPWR VPWR u_mem._0057_ sky130_fd_sc_hd__clkbuf_1
Xu_mem._0555_ u_mem._0179_ VGND VGND VPWR VPWR u_mem._0025_ sky130_fd_sc_hd__clkbuf_1
Xu_mem._0486_ net1 VGND VGND VPWR VPWR u_mem._0136_ sky130_fd_sc_hd__buf_2
Xu_mem._1038_ wr_clk u_mem._0066_ VGND VGND VPWR VPWR u_mem.mem\[11\]\[2\] sky130_fd_sc_hd__dfxtp_1
XFILLER_0_16_168 VGND VGND VPWR VPWR sky130_fd_sc_hd__decap_3
Xu_mem._1107_ wr_clk u_mem._0135_ VGND VGND VPWR VPWR u_mem.mem\[9\]\[7\] sky130_fd_sc_hd__dfxtp_1
XFILLER_0_22_116 VPWR VGND VPWR VGND sky130_ef_sc_hd__decap_12
XFILLER_0_42_46 VGND VGND VPWR VPWR sky130_fd_sc_hd__decap_3
XTAP_300 VGND VPWR sky130_fd_sc_hd__tapvpwrvgnd_1
XFILLER_0_6_57 VGND VGND VPWR VPWR sky130_fd_sc_hd__decap_8
XFILLER_0_21_160 VGND VGND VPWR VPWR sky130_fd_sc_hd__decap_4
Xu_mem._0538_ u_mem._0143_ u_mem.mem\[12\]\[2\] u_mem._0167_ VGND VGND VPWR VPWR u_mem._0170_
+ sky130_fd_sc_hd__mux2_1
XPHY_17 VGND VGND VPWR VPWR sky130_fd_sc_hd__decap_3
XPHY_28 VGND VGND VPWR VPWR sky130_fd_sc_hd__decap_3
Xu_mem._0607_ u_mem._0207_ VGND VGND VPWR VPWR u_mem._0049_ sky130_fd_sc_hd__clkbuf_1
Xu_sync_rd2wr._38_ net10 u_read.rd_ptr_gray\[4\] VGND VGND VPWR VPWR u_sync_rd2wr._19_
+ sky130_fd_sc_hd__and2b_1
XPHY_39 VGND VGND VPWR VPWR sky130_fd_sc_hd__decap_3
Xu_write._80_ u_write._16_ u_write._30_ u_write._39_ net10 VGND VGND VPWR VPWR u_write._07_
+ sky130_fd_sc_hd__a211oi_1
XFILLER_0_10_119 VGND VGND VPWR VPWR sky130_fd_sc_hd__decap_8
XFILLER_0_37_57 VPWR VGND VPWR VGND sky130_ef_sc_hd__decap_12
XFILLER_0_5_113 VPWR VGND VPWR VGND sky130_ef_sc_hd__decap_12
XFILLER_0_26_241 VGND VGND VPWR VPWR sky130_fd_sc_hd__decap_8
XTAP_130 VGND VPWR sky130_fd_sc_hd__tapvpwrvgnd_1
XTAP_141 VGND VPWR sky130_fd_sc_hd__tapvpwrvgnd_1
XTAP_152 VGND VPWR sky130_fd_sc_hd__tapvpwrvgnd_1
XTAP_163 VGND VPWR sky130_fd_sc_hd__tapvpwrvgnd_1
XTAP_174 VGND VPWR sky130_fd_sc_hd__tapvpwrvgnd_1
XTAP_185 VGND VPWR sky130_fd_sc_hd__tapvpwrvgnd_1
XTAP_196 VGND VPWR sky130_fd_sc_hd__tapvpwrvgnd_1
XFILLER_0_32_222 VPWR VGND VPWR VGND sky130_ef_sc_hd__decap_12
Xu_write._63_ u_write._29_ VGND VGND VPWR VPWR u_write._30_ sky130_fd_sc_hd__buf_2
Xu_mem._0941_ u_mem.mem\[5\]\[1\] net2 u_mem._0468_ VGND VGND VPWR VPWR u_mem._0470_
+ sky130_fd_sc_hd__mux2_1
XFILLER_0_23_222 VGND VGND VPWR VPWR sky130_fd_sc_hd__fill_2
Xu_mem._0872_ u_mem._0433_ VGND VGND VPWR VPWR u_mem._0088_ sky130_fd_sc_hd__clkbuf_1
XFILLER_0_3_69 VGND VGND VPWR VPWR sky130_fd_sc_hd__decap_6
Xu_write._46_ u_sync_rd2wr.gray_sync2\[3\] u_write._13_ VGND VGND VPWR VPWR u_write._14_
+ sky130_fd_sc_hd__xnor2_1
Xu_mem._1071_ wr_clk u_mem._0099_ VGND VGND VPWR VPWR u_mem.mem\[15\]\[3\] sky130_fd_sc_hd__dfxtp_1
Xu_mem._0924_ u_mem.mem\[0\]\[1\] net2 u_mem._0459_ VGND VGND VPWR VPWR u_mem._0461_
+ sky130_fd_sc_hd__mux2_1
XFILLER_0_11_225 VGND VGND VPWR VPWR sky130_fd_sc_hd__decap_8
XFILLER_0_45_7 VPWR VGND VPWR VGND sky130_ef_sc_hd__decap_12
Xu_mem._0855_ u_mem._0424_ VGND VGND VPWR VPWR u_mem._0080_ sky130_fd_sc_hd__clkbuf_1
Xu_mem._0786_ u_mem.mem\[14\]\[5\] u_mem.mem\[15\]\[5\] u_mem._0237_ VGND VGND VPWR
+ VPWR u_mem._0359_ sky130_fd_sc_hd__mux2_1
Xu_sync_wr2rd._43_ rd_clk u_sync_wr2rd._03_ VGND VGND VPWR VPWR u_read.wr_gray_sync2\[3\]
+ sky130_fd_sc_hd__dfxtp_1
Xu_mem._0571_ u_mem._0141_ u_mem.mem\[13\]\[1\] u_mem._0186_ VGND VGND VPWR VPWR u_mem._0188_
+ sky130_fd_sc_hd__mux2_1
Xu_mem._0640_ u_mem.mem\[11\]\[1\] net2 u_mem._0223_ VGND VGND VPWR VPWR u_mem._0225_
+ sky130_fd_sc_hd__mux2_1
XFILLER_0_45_57 VPWR VGND VPWR VGND sky130_ef_sc_hd__decap_12
Xu_mem._1054_ wr_clk u_mem._0082_ VGND VGND VPWR VPWR u_mem.mem\[1\]\[2\] sky130_fd_sc_hd__dfxtp_1
Xu_mem._0907_ u_mem.mem\[10\]\[1\] net2 u_mem._0450_ VGND VGND VPWR VPWR u_mem._0452_
+ sky130_fd_sc_hd__mux2_1
XFILLER_0_36_3 VGND VGND VPWR VPWR sky130_fd_sc_hd__decap_8
Xu_mem._0769_ u_mem.mem\[8\]\[4\] u_mem.mem\[9\]\[4\] u_mem._0248_ VGND VGND VPWR
+ VPWR u_mem._0343_ sky130_fd_sc_hd__mux2_1
Xu_mem._0838_ u_mem._0265_ u_mem._0408_ u_mem._0263_ VGND VGND VPWR VPWR u_mem._0409_
+ sky130_fd_sc_hd__a21oi_1
XFILLER_0_19_100 VGND VGND VPWR VPWR sky130_fd_sc_hd__decap_3
XFILLER_0_19_166 VGND VGND VPWR VPWR sky130_fd_sc_hd__fill_2
Xu_sync_wr2rd._26_ net10 u_sync_wr2rd.gray_sync1\[3\] VGND VGND VPWR VPWR u_sync_wr2rd._13_
+ sky130_fd_sc_hd__and2b_1
XFILLER_0_15_27 VPWR VGND VPWR VGND sky130_ef_sc_hd__decap_12
XFILLER_0_25_147 VPWR VGND VPWR VGND sky130_ef_sc_hd__decap_12
XFILLER_0_25_169 VGND VGND VPWR VPWR sky130_fd_sc_hd__decap_4
XFILLER_0_0_225 VPWR VGND VPWR VGND sky130_ef_sc_hd__decap_12
XFILLER_0_0_269 VGND VGND VPWR VPWR sky130_fd_sc_hd__fill_1
Xu_mem._0554_ u_mem.mem\[8\]\[1\] u_mem._0141_ u_mem._0177_ VGND VGND VPWR VPWR u_mem._0179_
+ sky130_fd_sc_hd__mux2_1
Xu_mem._0623_ u_mem.mem\[6\]\[1\] u_mem._0141_ u_mem._0214_ VGND VGND VPWR VPWR u_mem._0216_
+ sky130_fd_sc_hd__mux2_1
Xu_mem._1106_ wr_clk u_mem._0134_ VGND VGND VPWR VPWR u_mem.mem\[9\]\[6\] sky130_fd_sc_hd__dfxtp_1
Xu_mem._1037_ wr_clk u_mem._0065_ VGND VGND VPWR VPWR u_mem.mem\[11\]\[1\] sky130_fd_sc_hd__dfxtp_1
XFILLER_0_22_128 VGND VGND VPWR VPWR sky130_fd_sc_hd__decap_6
XFILLER_0_30_183 VGND VGND VPWR VPWR sky130_fd_sc_hd__decap_6
XFILLER_0_45_209 VPWR VGND VPWR VGND sky130_ef_sc_hd__decap_12
XFILLER_0_38_250 VGND VGND VPWR VPWR sky130_fd_sc_hd__fill_2
XTAP_301 VGND VPWR sky130_fd_sc_hd__tapvpwrvgnd_1
Xu_mem._0537_ u_mem._0169_ VGND VGND VPWR VPWR u_mem._0017_ sky130_fd_sc_hd__clkbuf_1
XPHY_18 VGND VGND VPWR VPWR sky130_fd_sc_hd__decap_3
Xu_mem._0606_ u_mem.mem\[7\]\[1\] u_mem._0141_ u_mem._0205_ VGND VGND VPWR VPWR u_mem._0207_
+ sky130_fd_sc_hd__mux2_1
XPHY_29 VGND VGND VPWR VPWR sky130_fd_sc_hd__decap_3
XFILLER_0_44_253 VPWR VGND VPWR VGND sky130_ef_sc_hd__decap_12
Xu_sync_rd2wr._37_ u_sync_rd2wr._18_ VGND VGND VPWR VPWR u_sync_rd2wr._08_ sky130_fd_sc_hd__clkbuf_1
XFILLER_0_8_188 VGND VGND VPWR VPWR sky130_fd_sc_hd__decap_8
XFILLER_0_12_172 VGND VGND VPWR VPWR sky130_fd_sc_hd__fill_1
XFILLER_0_10_109 VGND VGND VPWR VPWR sky130_fd_sc_hd__decap_6
XFILLER_0_37_69 VPWR VGND VPWR VGND sky130_ef_sc_hd__decap_12
XFILLER_0_5_125 VGND VGND VPWR VPWR sky130_fd_sc_hd__decap_4
XFILLER_0_26_253 VPWR VGND VPWR VGND sky130_ef_sc_hd__decap_12
XFILLER_0_5_169 VGND VGND VPWR VPWR sky130_fd_sc_hd__fill_2
XTAP_131 VGND VPWR sky130_fd_sc_hd__tapvpwrvgnd_1
XTAP_120 VGND VPWR sky130_fd_sc_hd__tapvpwrvgnd_1
XTAP_142 VGND VPWR sky130_fd_sc_hd__tapvpwrvgnd_1
XTAP_153 VGND VPWR sky130_fd_sc_hd__tapvpwrvgnd_1
XTAP_164 VGND VPWR sky130_fd_sc_hd__tapvpwrvgnd_1
XTAP_175 VGND VPWR sky130_fd_sc_hd__tapvpwrvgnd_1
XTAP_186 VGND VPWR sky130_fd_sc_hd__tapvpwrvgnd_1
XTAP_197 VGND VPWR sky130_fd_sc_hd__tapvpwrvgnd_1
Xu_write._62_ u_write._14_ u_write._18_ u_write._28_ net11 VGND VGND VPWR VPWR u_write._29_
+ sky130_fd_sc_hd__o31a_2
XFILLER_0_32_234 VPWR VGND VPWR VGND sky130_ef_sc_hd__decap_12
XFILLER_0_2_139 VGND VGND VPWR VPWR sky130_fd_sc_hd__fill_1
Xu_mem._0871_ u_mem._0136_ u_mem.mem\[14\]\[0\] u_mem._0432_ VGND VGND VPWR VPWR u_mem._0433_
+ sky130_fd_sc_hd__mux2_1
Xu_mem._0940_ u_mem._0469_ VGND VGND VPWR VPWR u_mem._0120_ sky130_fd_sc_hd__clkbuf_1
XFILLER_0_3_15 VPWR VGND VPWR VGND sky130_ef_sc_hd__decap_12
XFILLER_0_14_201 VGND VGND VPWR VPWR sky130_fd_sc_hd__fill_1
Xu_write._45_ u_write._10_ u_write._12_ VGND VGND VPWR VPWR u_write._13_ sky130_fd_sc_hd__xor2_1
Xu_read._96_ u_read.rd_ptr_bin\[4\] VGND VGND VPWR VPWR u_read.rd_ptr_gray\[4\] sky130_fd_sc_hd__clkbuf_1
XFILLER_0_34_26 VGND VGND VPWR VPWR sky130_fd_sc_hd__fill_2
XFILLER_0_7_209 VGND VGND VPWR VPWR sky130_fd_sc_hd__decap_8
Xu_mem._1070_ wr_clk u_mem._0098_ VGND VGND VPWR VPWR u_mem.mem\[15\]\[2\] sky130_fd_sc_hd__dfxtp_1
Xu_mem._0923_ u_mem._0460_ VGND VGND VPWR VPWR u_mem._0112_ sky130_fd_sc_hd__clkbuf_1
Xu_mem._0854_ u_mem.mem\[1\]\[0\] net1 u_mem._0423_ VGND VGND VPWR VPWR u_mem._0424_
+ sky130_fd_sc_hd__mux2_1
Xu_mem._0785_ u_mem._0234_ u_mem._0347_ u_mem._0357_ u_mem._0358_ VGND VGND VPWR VPWR
+ u_mem._0076_ sky130_fd_sc_hd__a31oi_1
Xu_sync_wr2rd._42_ rd_clk u_sync_wr2rd._02_ VGND VGND VPWR VPWR u_read.wr_gray_sync2\[2\]
+ sky130_fd_sc_hd__dfxtp_1
XFILLER_0_6_253 VGND VGND VPWR VPWR sky130_fd_sc_hd__decap_6
XFILLER_0_37_101 VGND VGND VPWR VPWR sky130_fd_sc_hd__decap_8
Xu_read._79_ u_mem.rd_addr\[0\] u_read._20_ u_read._38_ VGND VGND VPWR VPWR u_read._05_
+ sky130_fd_sc_hd__o21a_1
XFILLER_0_45_69 VGND VGND VPWR VPWR sky130_fd_sc_hd__decap_8
Xu_mem._0570_ u_mem._0187_ VGND VGND VPWR VPWR u_mem._0032_ sky130_fd_sc_hd__clkbuf_1
XFILLER_0_0_27 VGND VGND VPWR VPWR sky130_fd_sc_hd__fill_1
XFILLER_0_3_234 VPWR VGND VPWR VGND sky130_ef_sc_hd__decap_12
Xu_mem._1053_ wr_clk u_mem._0081_ VGND VGND VPWR VPWR u_mem.mem\[1\]\[1\] sky130_fd_sc_hd__dfxtp_1
Xu_mem._0906_ u_mem._0451_ VGND VGND VPWR VPWR u_mem._0104_ sky130_fd_sc_hd__clkbuf_1
Xu_mem._0837_ u_mem.mem\[10\]\[7\] u_mem.mem\[11\]\[7\] u_mem._0252_ VGND VGND VPWR
+ VPWR u_mem._0408_ sky130_fd_sc_hd__mux2_1
Xu_mem._0699_ u_mem._0236_ u_mem._0275_ VGND VGND VPWR VPWR u_mem._0276_ sky130_fd_sc_hd__nand2_1
Xu_mem._0768_ u_mem._0235_ u_mem._0340_ u_mem._0341_ u_mem._0245_ VGND VGND VPWR VPWR
+ u_mem._0342_ sky130_fd_sc_hd__o31a_1
XFILLER_0_29_3 VGND VGND VPWR VPWR sky130_fd_sc_hd__fill_2
Xu_sync_wr2rd._25_ u_sync_wr2rd._12_ VGND VGND VPWR VPWR u_sync_wr2rd._02_ sky130_fd_sc_hd__clkbuf_1
XFILLER_0_15_39 VPWR VGND VPWR VGND sky130_ef_sc_hd__decap_12
XFILLER_0_40_118 VGND VGND VPWR VPWR sky130_fd_sc_hd__decap_8
XFILLER_0_25_159 VGND VGND VPWR VPWR sky130_fd_sc_hd__decap_8
XFILLER_0_0_237 VPWR VGND VPWR VGND sky130_ef_sc_hd__decap_12
Xu_mem._0553_ u_mem._0178_ VGND VGND VPWR VPWR u_mem._0024_ sky130_fd_sc_hd__clkbuf_1
Xu_mem._0622_ u_mem._0215_ VGND VGND VPWR VPWR u_mem._0056_ sky130_fd_sc_hd__clkbuf_1
Xu_mem._1036_ wr_clk u_mem._0064_ VGND VGND VPWR VPWR u_mem.mem\[11\]\[0\] sky130_fd_sc_hd__dfxtp_1
Xu_mem._1105_ wr_clk u_mem._0133_ VGND VGND VPWR VPWR u_mem.mem\[9\]\[5\] sky130_fd_sc_hd__dfxtp_1
XFILLER_0_24_192 VGND VGND VPWR VPWR sky130_fd_sc_hd__decap_4
XFILLER_0_1_92 VPWR VGND VPWR VGND sky130_ef_sc_hd__decap_12
XFILLER_0_42_37 VGND VGND VPWR VPWR sky130_fd_sc_hd__decap_3
XFILLER_0_42_15 VPWR VGND VPWR VGND sky130_ef_sc_hd__decap_12
XFILLER_0_13_107 VGND VGND VPWR VPWR sky130_fd_sc_hd__decap_4
XTAP_302 VGND VPWR sky130_fd_sc_hd__tapvpwrvgnd_1
Xu_mem._0605_ u_mem._0206_ VGND VGND VPWR VPWR u_mem._0048_ sky130_fd_sc_hd__clkbuf_1
XFILLER_0_8_101 VGND VGND VPWR VPWR sky130_fd_sc_hd__decap_3
Xu_mem._0536_ u_mem._0141_ u_mem.mem\[12\]\[1\] u_mem._0167_ VGND VGND VPWR VPWR u_mem._0169_
+ sky130_fd_sc_hd__mux2_1
XPHY_19 VGND VGND VPWR VPWR sky130_fd_sc_hd__decap_3
XFILLER_0_16_82 VGND VGND VPWR VPWR sky130_fd_sc_hd__fill_2
XFILLER_0_20_7 VGND VGND VPWR VPWR sky130_fd_sc_hd__fill_1
XFILLER_0_44_265 VGND VGND VPWR VPWR sky130_fd_sc_hd__decap_4
Xu_sync_rd2wr._36_ net10 u_read.rd_ptr_gray\[3\] VGND VGND VPWR VPWR u_sync_rd2wr._18_
+ sky130_fd_sc_hd__and2b_1
XFILLER_0_8_178 VGND VGND VPWR VPWR sky130_fd_sc_hd__fill_1
XFILLER_0_29_251 VPWR VGND VPWR VGND sky130_ef_sc_hd__decap_12
Xu_mem._1019_ wr_clk u_mem._0047_ VGND VGND VPWR VPWR u_mem.mem\[2\]\[7\] sky130_fd_sc_hd__dfxtp_1
XFILLER_0_32_92 VGND VGND VPWR VPWR sky130_fd_sc_hd__fill_2
XFILLER_0_37_15 VGND VGND VPWR VPWR sky130_fd_sc_hd__decap_8
XFILLER_0_26_265 VGND VGND VPWR VPWR sky130_fd_sc_hd__fill_2
XTAP_132 VGND VPWR sky130_fd_sc_hd__tapvpwrvgnd_1
XTAP_121 VGND VPWR sky130_fd_sc_hd__tapvpwrvgnd_1
XTAP_110 VGND VPWR sky130_fd_sc_hd__tapvpwrvgnd_1
XTAP_143 VGND VPWR sky130_fd_sc_hd__tapvpwrvgnd_1
XTAP_154 VGND VPWR sky130_fd_sc_hd__tapvpwrvgnd_1
XTAP_165 VGND VPWR sky130_fd_sc_hd__tapvpwrvgnd_1
XTAP_176 VGND VPWR sky130_fd_sc_hd__tapvpwrvgnd_1
XTAP_187 VGND VPWR sky130_fd_sc_hd__tapvpwrvgnd_1
XTAP_198 VGND VPWR sky130_fd_sc_hd__tapvpwrvgnd_1
XFILLER_0_11_3 VPWR VGND VPWR VGND sky130_ef_sc_hd__decap_12
Xu_mem._0519_ u_mem._0159_ VGND VGND VPWR VPWR u_mem._0009_ sky130_fd_sc_hd__clkbuf_1
Xu_write._61_ u_write._14_ u_write._18_ u_write._28_ VGND VGND VPWR VPWR net21 sky130_fd_sc_hd__nor3_2
XFILLER_0_32_246 VGND VGND VPWR VPWR sky130_fd_sc_hd__decap_6
Xu_mem._0870_ u_mem.wr_addr\[0\] u_mem.wr_addr\[1\] u_mem._0166_ VGND VGND VPWR VPWR
+ u_mem._0432_ sky130_fd_sc_hd__nand3b_4
XFILLER_0_3_27 VPWR VGND VPWR VGND sky130_ef_sc_hd__decap_12
Xu_mem._0999_ wr_clk u_mem._0027_ VGND VGND VPWR VPWR u_mem.mem\[8\]\[3\] sky130_fd_sc_hd__dfxtp_1
Xu_write._44_ u_write.wr_ptr_bin\[4\] u_write._11_ VGND VGND VPWR VPWR u_write._12_
+ sky130_fd_sc_hd__xnor2_2
Xu_read._95_ rd_clk u_read._08_ VGND VGND VPWR VPWR u_mem.rd_addr\[3\] sky130_fd_sc_hd__dfxtp_4
Xu_mem._0922_ u_mem.mem\[0\]\[0\] net1 u_mem._0459_ VGND VGND VPWR VPWR u_mem._0460_
+ sky130_fd_sc_hd__mux2_1
XFILLER_0_11_238 VGND VGND VPWR VPWR sky130_fd_sc_hd__fill_2
Xu_mem._0784_ u_mem.dout\[4\] u_mem._0233_ VGND VGND VPWR VPWR u_mem._0358_ sky130_fd_sc_hd__nor2_1
Xu_mem._0853_ u_mem._0137_ u_mem._0422_ VGND VGND VPWR VPWR u_mem._0423_ sky130_fd_sc_hd__nor2_4
Xu_sync_wr2rd._41_ rd_clk u_sync_wr2rd._01_ VGND VGND VPWR VPWR u_read.wr_gray_sync2\[1\]
+ sky130_fd_sc_hd__dfxtp_1
XFILLER_0_37_113 VGND VGND VPWR VPWR sky130_fd_sc_hd__fill_2
XFILLER_0_37_146 VGND VGND VPWR VPWR sky130_fd_sc_hd__fill_2
XFILLER_0_20_29 VGND VGND VPWR VPWR sky130_fd_sc_hd__decap_3
Xu_read._78_ u_mem.rd_addr\[0\] u_read._20_ net10 VGND VGND VPWR VPWR u_read._38_
+ sky130_fd_sc_hd__a21oi_1
Xu_mem._1052_ wr_clk u_mem._0080_ VGND VGND VPWR VPWR u_mem.mem\[1\]\[0\] sky130_fd_sc_hd__dfxtp_1
XFILLER_0_3_246 VPWR VGND VPWR VGND sky130_ef_sc_hd__decap_12
Xu_mem._0905_ u_mem.mem\[10\]\[0\] net1 u_mem._0450_ VGND VGND VPWR VPWR u_mem._0451_
+ sky130_fd_sc_hd__mux2_1
Xu_mem._0767_ u_mem.mem\[13\]\[4\] u_mem._0266_ VGND VGND VPWR VPWR u_mem._0341_ sky130_fd_sc_hd__and2b_1
Xu_mem._0836_ u_mem._0247_ u_mem._0406_ VGND VGND VPWR VPWR u_mem._0407_ sky130_fd_sc_hd__or2b_1
Xu_mem._0698_ u_mem.mem\[14\]\[1\] u_mem.mem\[15\]\[1\] u_mem._0237_ VGND VGND VPWR
+ VPWR u_mem._0275_ sky130_fd_sc_hd__mux2_1
XFILLER_0_19_113 VGND VGND VPWR VPWR sky130_fd_sc_hd__fill_2
Xu_sync_wr2rd._24_ net10 u_sync_wr2rd.gray_sync1\[2\] VGND VGND VPWR VPWR u_sync_wr2rd._12_
+ sky130_fd_sc_hd__and2b_1
XFILLER_0_0_249 VGND VGND VPWR VPWR sky130_fd_sc_hd__decap_3
Xu_mem._0621_ u_mem.mem\[6\]\[0\] u_mem._0136_ u_mem._0214_ VGND VGND VPWR VPWR u_mem._0215_
+ sky130_fd_sc_hd__mux2_1
Xu_mem._0552_ u_mem.mem\[8\]\[0\] u_mem._0136_ u_mem._0177_ VGND VGND VPWR VPWR u_mem._0178_
+ sky130_fd_sc_hd__mux2_1
Xu_mem._1104_ wr_clk u_mem._0132_ VGND VGND VPWR VPWR u_mem.mem\[9\]\[4\] sky130_fd_sc_hd__dfxtp_1
Xu_mem._1035_ wr_clk u_mem._0063_ VGND VGND VPWR VPWR u_mem.mem\[6\]\[7\] sky130_fd_sc_hd__dfxtp_1
XFILLER_0_31_108 VGND VGND VPWR VPWR sky130_fd_sc_hd__decap_4
XFILLER_0_31_119 VGND VGND VPWR VPWR sky130_fd_sc_hd__fill_1
XFILLER_0_41_3 VPWR VGND VPWR VGND sky130_ef_sc_hd__decap_12
Xu_mem._0819_ u_mem._0236_ u_mem._0390_ VGND VGND VPWR VPWR u_mem._0391_ sky130_fd_sc_hd__nand2_1
XFILLER_0_30_141 VPWR VGND VPWR VGND sky130_ef_sc_hd__decap_12
XFILLER_0_42_27 VGND VGND VPWR VPWR sky130_fd_sc_hd__fill_1
XTAP_303 VGND VPWR sky130_fd_sc_hd__tapvpwrvgnd_1
XFILLER_0_6_27 VGND VGND VPWR VPWR sky130_fd_sc_hd__fill_1
XFILLER_0_21_130 VGND VGND VPWR VPWR sky130_fd_sc_hd__decap_8
Xu_mem._0604_ u_mem.mem\[7\]\[0\] u_mem._0136_ u_mem._0205_ VGND VGND VPWR VPWR u_mem._0206_
+ sky130_fd_sc_hd__mux2_1
Xu_sync_rd2wr._35_ u_sync_rd2wr._17_ VGND VGND VPWR VPWR u_sync_rd2wr._07_ sky130_fd_sc_hd__clkbuf_1
Xu_mem._0535_ u_mem._0168_ VGND VGND VPWR VPWR u_mem._0016_ sky130_fd_sc_hd__clkbuf_1
XFILLER_0_29_263 VGND VGND VPWR VPWR sky130_fd_sc_hd__decap_6
Xu_mem._1018_ wr_clk u_mem._0046_ VGND VGND VPWR VPWR u_mem.mem\[2\]\[6\] sky130_fd_sc_hd__dfxtp_1
XFILLER_0_32_82 VGND VGND VPWR VPWR sky130_fd_sc_hd__fill_2
XFILLER_0_35_266 VGND VGND VPWR VPWR sky130_fd_sc_hd__decap_4
XFILLER_0_41_225 VGND VGND VPWR VPWR sky130_fd_sc_hd__decap_6
XTAP_133 VGND VPWR sky130_fd_sc_hd__tapvpwrvgnd_1
XTAP_122 VGND VPWR sky130_fd_sc_hd__tapvpwrvgnd_1
XTAP_111 VGND VPWR sky130_fd_sc_hd__tapvpwrvgnd_1
XTAP_100 VGND VPWR sky130_fd_sc_hd__tapvpwrvgnd_1
XTAP_144 VGND VPWR sky130_fd_sc_hd__tapvpwrvgnd_1
XTAP_155 VGND VPWR sky130_fd_sc_hd__tapvpwrvgnd_1
XTAP_166 VGND VPWR sky130_fd_sc_hd__tapvpwrvgnd_1
.ends
